* SPDX-FileCopyrightText: 2026 Christoph Maier
* SPDX-License-Identifier: Apache-2.0
* magic C-coupled PEX (sak-pex.sh -m 2) of pads/sg13cmos5l_IOPadDiff2Single/sg13cmos5l_IOPadDiff2Single.gds (taped-out cell),
* vss port added (pex_add_port.py, 1 Ohm to iovss), ports in symbol order (sak-pin-reorder.py). Generated by run.sh.
* PEX produced on Mon Nov 23 20:42:40 UTC 2026 using /usr/local/bin/sak-pex.sh with m=2 and s=1
* NGSPICE file created from sg13cmos5l_IOPadDiff2Single_pex.ext - technology: ihp-sg13cmos5l

.subckt sg13cmos5l_IOPadDiff2Single_pex iovdd iovss vdd vss pad vinp vinn vref
+ iref en_3v3 en_3v3_b
X0 iovdd d2s_block_0.bias_tree_n_f2_0.vbpc iovdd iovdd sg13_hv_pmos ad=0.34p pd=2.68u as=0.90339n ps=3.59803m w=1u l=4u
X1 pad d2s_cma_0.a iovdd iovdd sg13_hv_pmos ad=3.9294p pd=7.84u as=2.1312p ps=7.3u w=6.66u l=0.6u
X2 pad Clamp_N_M1_wiring_0.b iovss iovss sg13_hv_nmos ad=2.596p pd=5.58u as=1.408p ps=5.04u w=4.4u l=1u
X3 d2s_block_0.d2s_sp2k_f2_1.core d2s_cma_0.a d2s_block_0.d2s_sp2k_f2_1.core d2s_block_0.d2s_sp2k_f2_1.core sg13_hv_pmos ad=2.7064p pd=16.6u as=40.5004p ps=0.1292m w=7.96u l=32.16u
X4 d2s_block_0.bias_tree_n_f2_0.ni en_3v3_b iref iovdd sg13_hv_pmos ad=0.34p pd=2.68u as=0.34p ps=2.68u w=1u l=0.45u
X5 iovss pad dantenna l=1.26u w=67.6u
X6 pad d2s_cma_0.a iovdd iovdd sg13_hv_pmos ad=3.9294p pd=7.84u as=2.1312p ps=7.3u w=6.66u l=0.6u
X7 d2s_block_0.sinks_6x6_f2_0.vbn d2s_block_0.sinks_6x6_f2_0.vbn d2s_block_0.sinks_6x6_f2_0.vbn iovss sg13_hv_nmos ad=0.68p pd=4.68u as=31.08205p ps=0.23533m w=2u l=6u
X8 iovss en_3v3_b Clamp_N_M1_wiring_0.b iovss sg13_hv_nmos ad=0.34p pd=2.68u as=0.34p ps=2.68u w=1u l=0.45u
X9 d2s_block_0.d2s_sp2k_f2_0.core pad iovss rppd l=7.435u w=1u
X10 iovdd d2s_cma_0.a pad iovdd sg13_hv_pmos ad=2.1312p pd=7.3u as=3.9294p ps=7.84u w=6.66u l=0.6u
X11 iovss Clamp_N_M1_wiring_0.b pad iovss sg13_hv_nmos ad=1.408p pd=5.04u as=2.596p ps=5.58u w=4.4u l=1u
X12 iovss d2s_block_0.sinks_6x6_f2_0.vbn d2s_block_0.d2s_casc_n_f2_0.y iovss sg13_hv_nmos ad=2.04p pd=12.68u as=2.04p ps=12.68u w=6u l=6u
X13 d2s_block_0.d2s_ab_n_f2_0.l1 d2s_block_0.bias_tree_n_f2_0.vabp d2s_block_0.d2s_ab_n_f2_0.l2 iovdd sg13_hv_pmos ad=2.2644p pd=14u as=2.2644p ps=14u w=6.66u l=0.6u
X14 d2s_block_0.d2s_ab_n_f2_0.l1 d2s_block_0.d2s_ab_n_f2_0.vabn d2s_block_0.d2s_ab_n_f2_0.l2 iovss sg13_hv_nmos ad=1.496p pd=9.48u as=1.496p ps=9.48u w=4.4u l=1u
X15 pad d2s_cma_0.a iovdd iovdd sg13_hv_pmos ad=3.9294p pd=7.84u as=2.1312p ps=7.3u w=6.66u l=0.6u
X16 pad Clamp_N_M1_wiring_0.b iovss iovss sg13_hv_nmos ad=2.596p pd=5.58u as=1.408p ps=5.04u w=4.4u l=1u
X17 d2s_block_0.d2s_casc_n_f2_0.y vref d2s_block_0.d2s_rhigh_f2_0.sa_C2 d2s_block_0.d2s_rhigh_f2_0.sa_C2 sg13_hv_pmos ad=1.9p pd=10.38u as=3.4p ps=20.68u w=10u l=1u
X18 iovss d2s_block_0.sinks_6x6_f2_0.vbn d2s_block_0.d2s_casc_n_f2_0.x iovss sg13_hv_nmos ad=2.04p pd=12.68u as=2.04p ps=12.68u w=6u l=6u
X19 iovdd d2s_block_0.d2s_ab_n_f2_0.l2 d2s_block_0.d2s_casc_p_c2_0.pr iovdd sg13_hv_pmos ad=2.04p pd=12.68u as=2.04p ps=12.68u w=6u l=4u
X20 pad d2s_cma_0.a iovdd iovdd sg13_hv_pmos ad=3.9294p pd=7.84u as=2.1312p ps=7.3u w=6.66u l=0.6u
X21 pad iovdd dpantenna l=1.26u w=65.8u
X22 iovss d2s_block_0.d2s_casc_n_f2_0.vbnc d2s_block_0.d2s_casc_n_f2_0.vbnc iovss sg13_hv_nmos ad=0.34p pd=2.68u as=0.34p ps=2.68u w=1u l=8u
X23 pad d2s_cma_0.a iovdd iovdd sg13_hv_pmos ad=4.9284p pd=14.8u as=2.1312p ps=7.3u w=6.66u l=0.6u
X24 d2s_block_0.d2s_casc_n_f2_0.x pad d2s_block_0.d2s_rhigh_f2_0.sb_C2 d2s_block_0.d2s_rhigh_f2_0.sb_C2 sg13_hv_pmos ad=1.9p pd=10.38u as=3.4p ps=20.68u w=10u l=1u
X25 iovss Clamp_N_M1_wiring_0.b pad iovss sg13_hv_nmos ad=1.408p pd=5.04u as=2.596p ps=5.58u w=4.4u l=1u
X26 pad d2s_cma_0.a iovdd iovdd sg13_hv_pmos ad=3.9294p pd=7.84u as=2.1312p ps=7.3u w=6.66u l=0.6u
X27 pad Clamp_N_M1_wiring_0.b iovss iovss sg13_hv_nmos ad=2.596p pd=5.58u as=1.408p ps=5.04u w=4.4u l=1u
X28 pad Clamp_N_M1_wiring_0.b iovss iovss sg13_hv_nmos ad=2.596p pd=5.58u as=1.408p ps=5.04u w=4.4u l=1u
X29 iovdd d2s_cma_0.a pad iovdd sg13_hv_pmos ad=2.1312p pd=7.3u as=3.9294p ps=7.84u w=6.66u l=0.6u
X30 iovdd d2s_cma_0.a pad iovdd sg13_hv_pmos ad=2.1312p pd=7.3u as=3.9294p ps=7.84u w=6.66u l=0.6u
X31 d2s_block_0.d2s_casc_p_c2_0.pr d2s_block_0.bias_tree_n_f2_0.vbpc d2s_cma_0.a iovdd sg13_hv_pmos ad=5.1p pd=30.68u as=5.1p ps=30.68u w=15u l=3u
X32 d2s_block_0.d2s_casc_p_c2_0.pl d2s_block_0.d2s_ab_n_f2_0.l2 iovdd iovdd sg13_hv_pmos ad=2.04p pd=12.68u as=2.04p ps=12.68u w=6u l=4u
X33 iovdd d2s_cma_0.a pad iovdd sg13_hv_pmos ad=2.1312p pd=7.3u as=3.9294p ps=7.84u w=6.66u l=0.6u
X34 iovss Clamp_N_M1_wiring_0.b pad iovss sg13_hv_nmos ad=1.408p pd=5.04u as=2.596p ps=5.58u w=4.4u l=1u
X35 iovss Clamp_N_M1_wiring_0.b pad iovss sg13_hv_nmos ad=1.408p pd=5.04u as=2.596p ps=5.58u w=4.4u l=1u
X36 iovss Clamp_N_M1_wiring_0.b pad iovss sg13_hv_nmos ad=1.408p pd=5.04u as=2.596p ps=5.58u w=4.4u l=1u
X37 iovdd d2s_cma_0.a pad iovdd sg13_hv_pmos ad=2.1312p pd=7.3u as=3.9294p ps=7.84u w=6.66u l=0.6u
X38 pad d2s_cma_0.a iovdd iovdd sg13_hv_pmos ad=3.9294p pd=7.84u as=2.1312p ps=7.3u w=6.66u l=0.6u
X39 pad d2s_cma_0.a iovdd iovdd sg13_hv_pmos ad=3.9294p pd=7.84u as=2.1312p ps=7.3u w=6.66u l=0.6u
X40 pad Clamp_N_M1_wiring_0.b iovss iovss sg13_hv_nmos ad=2.596p pd=5.58u as=1.408p ps=5.04u w=4.4u l=1u
X41 iovdd d2s_block_0.d2s_ab_n_f2_0.l2 d2s_block_0.d2s_casc_p_c2_0.pr iovdd sg13_hv_pmos ad=2.04p pd=12.68u as=2.04p ps=12.68u w=6u l=4u
X42 pad Clamp_N_M1_wiring_0.b iovss iovss sg13_hv_nmos ad=2.596p pd=5.58u as=1.408p ps=5.04u w=4.4u l=1u
X43 iovdd d2s_cma_0.a pad iovdd sg13_hv_pmos ad=2.1312p pd=7.3u as=3.9294p ps=7.84u w=6.66u l=0.6u
X44 iovdd d2s_block_0.bias_tree_n_f2_0.vbp d2s_block_0.d2s_ab_n_f2_0.vabn iovdd sg13_hv_pmos ad=1.7p pd=10.68u as=1.7p ps=10.68u w=5u l=6u
X45 a_10598_32196# a_10462_29580# iovss rhigh l=12.65u w=0.5u
X46 iovdd d2s_block_0.bias_tree_n_f2_0.vbpc d2s_block_0.bias_tree_n_f2_0.vbpc iovdd sg13_hv_pmos ad=0.34p pd=2.68u as=0.34p ps=2.68u w=1u l=4u
X47 pad d2s_cma_0.a iovdd iovdd sg13_hv_pmos ad=3.9294p pd=7.84u as=2.1312p ps=7.3u w=6.66u l=0.6u
X48 iovss Clamp_N_M1_wiring_0.b pad iovss sg13_hv_nmos ad=1.408p pd=5.04u as=2.596p ps=5.58u w=4.4u l=1u
X49 iovss d2s_block_0.bias_tree_n_f2_0.ni d2s_block_0.bias_tree_n_f2_0.vbp iovss sg13_hv_nmos ad=2.04p pd=12.68u as=2.04p ps=12.68u w=6u l=6u
X50 iovss d2s_block_0.bias_tree_n_f2_0.ni d2s_block_0.bias_tree_n_f2_0.ni iovss sg13_hv_nmos ad=2.04p pd=12.68u as=2.04p ps=12.68u w=6u l=6u
X51 pad Clamp_N_M1_wiring_0.b iovss iovss sg13_hv_nmos ad=2.596p pd=5.58u as=1.408p ps=5.04u w=4.4u l=1u
X52 Clamp_N_M1_wiring_0.b d2s_block_0.d2s_sp2k_f2_0.core Clamp_N_M1_wiring_0.b Clamp_N_M1_wiring_0.b sg13_hv_pmos ad=2.7064p pd=16.6u as=0.35189n ps=1.20463m w=7.96u l=32.16u
X53 d2s_block_0.sinks_6x6_f2_0.vbn d2s_block_0.sinks_6x6_f2_0.vbn d2s_block_0.sinks_6x6_f2_0.vbn iovss sg13_hv_nmos ad=0.68p pd=4.68u as=0 ps=0 w=2u l=6u
X54 d2s_block_0.d2s_casc_p_c2_0.pl d2s_block_0.d2s_ab_n_f2_0.l2 iovdd iovdd sg13_hv_pmos ad=2.04p pd=12.68u as=2.04p ps=12.68u w=6u l=4u
X55 iovdd d2s_cma_0.a pad iovdd sg13_hv_pmos ad=2.1312p pd=7.3u as=3.9294p ps=7.84u w=6.66u l=0.6u
X56 pad Clamp_N_M1_wiring_0.b iovss iovss sg13_hv_nmos ad=2.596p pd=5.58u as=1.408p ps=5.04u w=4.4u l=1u
X57 pad d2s_cma_0.a iovdd iovdd sg13_hv_pmos ad=3.9294p pd=7.84u as=2.1312p ps=7.3u w=6.66u l=0.6u
X58 iovdd d2s_cma_0.a pad iovdd sg13_hv_pmos ad=2.1312p pd=7.3u as=3.9294p ps=7.84u w=6.66u l=0.6u
X59 iovss Clamp_N_M1_wiring_0.b pad iovss sg13_hv_nmos ad=1.408p pd=5.04u as=2.596p ps=5.58u w=4.4u l=1u
X60 iovss d2s_block_0.d2s_sp2k_f2_1.core dantenna l=3.1u w=0.64u
X61 d2s_block_0.d2s_rhigh_f2_0.sb_A d2s_block_0.bias_tree_n_f2_0.vbp iovdd iovdd sg13_hv_pmos ad=1.7p pd=10.68u as=1.7p ps=10.68u w=5u l=6u
X62 iovss d2s_block_0.sinks_6x6_f2_0.vbn d2s_block_0.d2s_casc_n_f2_0.y iovss sg13_hv_nmos ad=2.04p pd=12.68u as=2.04p ps=12.68u w=6u l=6u
X63 d2s_block_0.d2s_rhigh_f2_0.sa_B vref d2s_block_0.d2s_casc_n_f2_0.y d2s_block_0.d2s_rhigh_f2_0.sa_B sg13_hv_pmos ad=3.4p pd=20.68u as=1.9p ps=10.38u w=10u l=1u
X64 d2s_block_0.d2s_casc_n_f2_0.y vref d2s_block_0.d2s_rhigh_f2_0.sa_C1 d2s_block_0.d2s_rhigh_f2_0.sa_C1 sg13_hv_pmos ad=1.9p pd=10.38u as=3.4p ps=20.68u w=10u l=1u
X65 d2s_block_0.d2s_casc_n_f2_0.y d2s_block_0.sinks_6x6_f2_0.vbn iovss iovss sg13_hv_nmos ad=2.04p pd=12.68u as=2.04p ps=12.68u w=6u l=6u
X66 iovdd d2s_cma_0.a pad iovdd sg13_hv_pmos ad=2.1312p pd=7.3u as=3.9294p ps=7.84u w=6.66u l=0.6u
X67 pad d2s_cma_0.a iovdd iovdd sg13_hv_pmos ad=3.9294p pd=7.84u as=2.1312p ps=7.3u w=6.66u l=0.6u
X68 iovdd d2s_block_0.bias_tree_n_f2_0.vbp iovdd iovdd sg13_hv_pmos ad=0.68p pd=4.68u as=0 ps=0 w=2u l=6u
X69 d2s_block_0.bias_tree_n_f2_0.ni en_3v3 iref iovss sg13_hv_nmos ad=0.34p pd=2.68u as=0.34p ps=2.68u w=1u l=0.45u
X70 pad Clamp_N_M1_wiring_0.b iovss iovss sg13_hv_nmos ad=2.596p pd=5.58u as=1.408p ps=5.04u w=4.4u l=1u
X71 iovdd en_3v3 d2s_cma_0.a iovdd sg13_hv_pmos ad=0.34p pd=2.68u as=0.34p ps=2.68u w=1u l=0.45u
X72 pad iovdd dpantenna l=1.26u w=65.8u
X73 d2s_block_0.bias_tree_n_f2_0.ni en_3v3_b iovss iovss sg13_hv_nmos ad=0.34p pd=2.68u as=0.34p ps=2.68u w=1u l=0.45u
X74 d2s_block_0.d2s_sp2k_f2_1.core pad iovss rppd l=7.435u w=1u
X75 iovdd d2s_cma_0.a pad iovdd sg13_hv_pmos ad=2.1312p pd=7.3u as=3.9294p ps=7.84u w=6.66u l=0.6u
X76 iovss Clamp_N_M1_wiring_0.b pad iovss sg13_hv_nmos ad=1.408p pd=5.04u as=2.596p ps=5.58u w=4.4u l=1u
X77 iovss Clamp_N_M1_wiring_0.b pad iovss sg13_hv_nmos ad=1.408p pd=5.04u as=2.596p ps=5.58u w=4.4u l=1u
X78 iovdd d2s_cma_0.a pad iovdd sg13_hv_pmos ad=2.1312p pd=7.3u as=3.9294p ps=7.84u w=6.66u l=0.6u
X79 d2s_block_0.d2s_rhigh_f2_0.sb_C1 pad d2s_block_0.d2s_casc_n_f2_0.x d2s_block_0.d2s_rhigh_f2_0.sb_C1 sg13_hv_pmos ad=3.4p pd=20.68u as=1.9p ps=10.38u w=10u l=1u
X80 a_9510_32196# d2s_block_0.d2s_rhigh_f2_0.sa_A iovss rhigh l=12.65u w=0.5u
X81 iovdd iovdd iovdd iovdd sg13_hv_pmos ad=3.4p pd=20.68u as=0 ps=0 w=10u l=1u
X82 iovdd d2s_block_0.bias_tree_n_f2_0.vbp iovdd iovdd sg13_hv_pmos ad=1.7p pd=10.68u as=0 ps=0 w=5u l=6u
X83 iovss Clamp_N_M1_wiring_0.b pad iovss sg13_hv_nmos ad=1.408p pd=5.04u as=2.596p ps=5.58u w=4.4u l=1u
X84 d2s_block_0.d2s_ab_n_f2_0.l2 d2s_block_0.bias_tree_n_f2_0.vbpc d2s_block_0.d2s_casc_p_c2_0.pl iovdd sg13_hv_pmos ad=5.1p pd=30.68u as=5.1p ps=30.68u w=15u l=3u
X85 pad d2s_cma_0.a iovdd iovdd sg13_hv_pmos ad=3.9294p pd=7.84u as=2.1312p ps=7.3u w=6.66u l=0.6u
X86 iovdd d2s_cma_0.a pad iovdd sg13_hv_pmos ad=2.1312p pd=7.3u as=3.9294p ps=7.84u w=6.66u l=0.6u
X87 iovdd iovdd iovdd iovdd sg13_hv_pmos ad=2.2644p pd=14u as=0 ps=0 w=6.66u l=0.6u
X88 iovss Clamp_N_M1_wiring_0.b pad iovss sg13_hv_nmos ad=1.408p pd=5.04u as=2.596p ps=5.58u w=4.4u l=1u
X89 pad Clamp_N_M1_wiring_0.b iovss iovss sg13_hv_nmos ad=2.596p pd=5.58u as=2.068p ps=9.74u w=4.4u l=1u
X90 pad Clamp_N_M1_wiring_0.b iovss iovss sg13_hv_nmos ad=2.596p pd=5.58u as=1.408p ps=5.04u w=4.4u l=1u
X91 iovss d2s_block_0.bias_tree_n_f2_0.ni d2s_block_0.bias_tree_n_f2_0.vbpc iovss sg13_hv_nmos ad=0.816p pd=5.48u as=0.816p ps=5.48u w=2.4u l=6u
X92 a_10734_32196# d2s_block_0.d2s_rhigh_f2_0.sb_B iovss rhigh l=12.65u w=0.5u
X93 Clamp_P_M1_wiring_0.dabp d2s_block_0.bias_tree_n_f2_0.vabp d2s_block_0.bias_tree_n_f2_0.vabp iovdd sg13_hv_pmos ad=2.2644p pd=14u as=2.2644p ps=14u w=6.66u l=0.6u
X94 pad d2s_cma_0.a iovdd iovdd sg13_hv_pmos ad=3.9294p pd=7.84u as=2.1312p ps=7.3u w=6.66u l=0.6u
X95 d2s_block_0.d2s_rhigh_f2_0.sa_C1 d2s_block_0.bias_tree_n_f2_0.vbp iovdd iovdd sg13_hv_pmos ad=1.7p pd=10.68u as=1.7p ps=10.68u w=5u l=6u
X96 a_11006_32196# a_10054_29580# iovss rhigh l=12.65u w=0.5u
X97 pad d2s_cma_0.a iovdd iovdd sg13_hv_pmos ad=3.9294p pd=7.84u as=2.1312p ps=7.3u w=6.66u l=0.6u
X98 iovss Clamp_N_M1_wiring_0.b pad iovss sg13_hv_nmos ad=1.408p pd=5.04u as=2.596p ps=5.58u w=4.4u l=1u
X99 iovss Clamp_N_M1_wiring_0.b pad iovss sg13_hv_nmos ad=1.408p pd=5.04u as=2.596p ps=5.58u w=4.4u l=1u
X100 iovdd d2s_cma_0.a pad iovdd sg13_hv_pmos ad=2.1312p pd=7.3u as=3.9294p ps=7.84u w=6.66u l=0.6u
X101 iovdd d2s_block_0.bias_tree_n_f2_0.vbp d2s_block_0.sinks_6x6_f2_0.vbn iovdd sg13_hv_pmos ad=1.7p pd=10.68u as=1.7p ps=10.68u w=5u l=6u
X102 d2s_block_0.d2s_rhigh_f2_0.sb_A vref d2s_block_0.d2s_casc_n_f2_0.x d2s_block_0.d2s_rhigh_f2_0.sb_A sg13_hv_pmos ad=3.4p pd=20.68u as=1.9p ps=10.38u w=10u l=1u
X103 Clamp_N_M1_wiring_0.b d2s_block_0.d2s_ab_n_f2_0.vabn d2s_cma_0.a iovss sg13_hv_nmos ad=1.496p pd=9.48u as=1.496p ps=9.48u w=4.4u l=1u
X104 pad Clamp_N_M1_wiring_0.b iovss iovss sg13_hv_nmos ad=3.256p pd=10.28u as=1.408p ps=5.04u w=4.4u l=1u
X105 d2s_block_0.d2s_casc_n_f2_0.y vinp d2s_block_0.d2s_rhigh_f2_0.sa_A d2s_block_0.d2s_rhigh_f2_0.sa_A sg13_hv_pmos ad=1.9p pd=10.38u as=3.4p ps=20.68u w=10u l=1u
X106 pad Clamp_N_M1_wiring_0.b iovss iovss sg13_hv_nmos ad=2.596p pd=5.58u as=1.408p ps=5.04u w=4.4u l=1u
X107 d2s_block_0.d2s_casc_n_f2_0.y d2s_block_0.sinks_6x6_f2_0.vbn iovss iovss sg13_hv_nmos ad=2.04p pd=12.68u as=2.04p ps=12.68u w=6u l=6u
X108 iovdd d2s_cma_0.a pad iovdd sg13_hv_pmos ad=2.1312p pd=7.3u as=3.9294p ps=7.84u w=6.66u l=0.6u
X109 d2s_block_0.sinks_6x6_f2_0.vbn d2s_block_0.sinks_6x6_f2_0.vbn d2s_block_0.sinks_6x6_f2_0.vbn iovss sg13_hv_nmos ad=2.04p pd=12.68u as=0 ps=0 w=6u l=6u
X110 d2s_block_0.sinks_6x6_f2_0.vbn d2s_block_0.sinks_6x6_f2_0.vbn d2s_block_0.sinks_6x6_f2_0.vbn iovss sg13_hv_nmos ad=0.68p pd=4.68u as=0 ps=0 w=2u l=6u
X111 iovss Clamp_N_M1_wiring_0.b pad iovss sg13_hv_nmos ad=1.408p pd=5.04u as=2.596p ps=5.58u w=4.4u l=1u
X112 d2s_block_0.d2s_casc_n_f2_0.vbnc d2s_block_0.d2s_casc_n_f2_0.vbnc d2s_block_0.d2s_casc_n_f2_0.vbnc iovss sg13_hv_nmos ad=0.68p pd=4.68u as=19.07282p ps=0.15628m w=2u l=3u
X113 iovss iovss iovss iovss sg13_hv_nmos ad=1.496p pd=9.48u as=0.8943n ps=3.44684m w=4.4u l=1u
X114 d2s_block_0.d2s_sp2k_f2_0.core iovdd dpantenna l=0.64u w=4.98u
X115 iovdd d2s_cma_0.a pad iovdd sg13_hv_pmos ad=2.1312p pd=7.3u as=3.9294p ps=7.84u w=6.66u l=0.6u
X116 iovdd Clamp_P_M1_wiring_0.dabp Clamp_P_M1_wiring_0.dabp iovdd sg13_hv_pmos ad=2.1312p pd=7.3u as=3.9294p ps=7.84u w=6.66u l=0.6u
X117 iovdd d2s_block_0.d2s_ab_n_f2_0.l2 iovdd iovdd sg13_hv_pmos ad=0.34p pd=2.68u as=0 ps=0 w=1u l=4u
X118 pad d2s_cma_0.a iovdd iovdd sg13_hv_pmos ad=3.9294p pd=7.84u as=2.1312p ps=7.3u w=6.66u l=0.6u
X119 iovdd d2s_cma_0.a pad iovdd sg13_hv_pmos ad=2.1312p pd=7.3u as=3.9294p ps=7.84u w=6.66u l=0.6u
X120 d2s_block_0.d2s_rhigh_f2_0.sa_C2 vref d2s_block_0.d2s_casc_n_f2_0.y d2s_block_0.d2s_rhigh_f2_0.sa_C2 sg13_hv_pmos ad=3.4p pd=20.68u as=1.9p ps=10.38u w=10u l=1u
X121 d2s_block_0.d2s_rhigh_f2_0.sa_C2 d2s_block_0.bias_tree_n_f2_0.vbp iovdd iovdd sg13_hv_pmos ad=1.7p pd=10.68u as=1.7p ps=10.68u w=5u l=6u
X122 d2s_block_0.d2s_rhigh_f2_0.sa_A vinp d2s_block_0.d2s_casc_n_f2_0.y d2s_block_0.d2s_rhigh_f2_0.sa_A sg13_hv_pmos ad=3.4p pd=20.68u as=1.9p ps=10.38u w=10u l=1u
X123 Clamp_N_M1_wiring_0.b d2s_block_0.d2s_casc_n_f2_0.vbnc d2s_block_0.d2s_casc_n_f2_0.y iovss sg13_hv_nmos ad=5.1p pd=30.68u as=5.1p ps=30.68u w=15u l=3u
X124 iovss Clamp_N_M1_wiring_0.b pad iovss sg13_hv_nmos ad=1.408p pd=5.04u as=2.596p ps=5.58u w=4.4u l=1u
X125 iovdd iovdd iovdd iovdd sg13_hv_pmos ad=3.4p pd=20.68u as=0 ps=0 w=10u l=1u
X126 iovss d2s_block_0.sinks_6x6_f2_0.vbn d2s_block_0.d2s_casc_n_f2_0.x iovss sg13_hv_nmos ad=2.04p pd=12.68u as=2.04p ps=12.68u w=6u l=6u
X127 pad d2s_cma_0.a iovdd iovdd sg13_hv_pmos ad=3.9294p pd=7.84u as=2.1312p ps=7.3u w=6.66u l=0.6u
X128 pad Clamp_N_M1_wiring_0.b iovss iovss sg13_hv_nmos ad=2.596p pd=5.58u as=1.408p ps=5.04u w=4.4u l=1u
X129 pad Clamp_N_M1_wiring_0.b iovss iovss sg13_hv_nmos ad=2.596p pd=5.58u as=1.408p ps=5.04u w=4.4u l=1u
X130 iovdd d2s_cma_0.a pad iovdd sg13_hv_pmos ad=2.1312p pd=7.3u as=3.9294p ps=7.84u w=6.66u l=0.6u
X131 pad d2s_cma_0.a iovdd iovdd sg13_hv_pmos ad=3.9294p pd=7.84u as=2.1312p ps=7.3u w=6.66u l=0.6u
X132 pad Clamp_N_M1_wiring_0.b iovss iovss sg13_hv_nmos ad=2.596p pd=5.58u as=1.408p ps=5.04u w=4.4u l=1u
X133 a_10598_32196# d2s_block_0.d2s_rhigh_f2_0.sb_A iovss rhigh l=12.65u w=0.5u
X134 iovdd d2s_block_0.d2s_ab_n_f2_0.l2 iovdd iovdd sg13_hv_pmos ad=0.34p pd=2.68u as=0 ps=0 w=1u l=4u
X135 iovdd d2s_cma_0.a pad iovdd sg13_hv_pmos ad=2.1312p pd=7.3u as=3.9294p ps=7.84u w=6.66u l=0.6u
X136 pad d2s_cma_0.a iovdd iovdd sg13_hv_pmos ad=3.9294p pd=7.84u as=3.1302p ps=14.26u w=6.66u l=0.6u
X137 iovdd d2s_block_0.bias_tree_n_f2_0.vbp iovdd iovdd sg13_hv_pmos ad=1.7p pd=10.68u as=0 ps=0 w=5u l=6u
X138 a_11006_32196# d2s_block_0.d2s_rhigh_f2_0.sb_C2 iovss rhigh l=12.65u w=0.5u
X139 iovss Clamp_N_M1_wiring_0.b pad iovss sg13_hv_nmos ad=1.408p pd=5.04u as=2.596p ps=5.58u w=4.4u l=1u
X140 iovss Clamp_N_M1_wiring_0.b pad iovss sg13_hv_nmos ad=1.408p pd=5.04u as=2.596p ps=5.58u w=4.4u l=1u
X141 iovss Clamp_N_M1_wiring_0.b pad iovss sg13_hv_nmos ad=1.408p pd=5.04u as=2.596p ps=5.58u w=4.4u l=1u
X142 pad d2s_cma_0.a iovdd iovdd sg13_hv_pmos ad=3.9294p pd=7.84u as=2.1312p ps=7.3u w=6.66u l=0.6u
X143 pad Clamp_N_M1_wiring_0.b iovss iovss sg13_hv_nmos ad=2.596p pd=5.58u as=1.408p ps=5.04u w=4.4u l=1u
X144 d2s_block_0.d2s_casc_n_f2_0.vbnc d2s_block_0.d2s_casc_n_f2_0.vbnc d2s_block_0.d2s_casc_n_f2_0.vbnc iovss sg13_hv_nmos ad=0.68p pd=4.68u as=0 ps=0 w=2u l=3u
X145 pad Clamp_N_M1_wiring_0.b iovss iovss sg13_hv_nmos ad=2.596p pd=5.58u as=1.408p ps=5.04u w=4.4u l=1u
X146 iovdd iovdd iovdd iovdd sg13_hv_pmos ad=1.9p pd=10.38u as=0 ps=0 w=10u l=1u
X147 iovdd d2s_cma_0.a pad iovdd sg13_hv_pmos ad=2.1312p pd=7.3u as=3.9294p ps=7.84u w=6.66u l=0.6u
X148 d2s_block_0.d2s_casc_n_f2_0.x vinn d2s_block_0.d2s_rhigh_f2_0.sb_B d2s_block_0.d2s_rhigh_f2_0.sb_B sg13_hv_pmos ad=1.9p pd=10.38u as=3.4p ps=20.68u w=10u l=1u
X149 iovdd d2s_block_0.d2s_ab_n_f2_0.l2 d2s_block_0.d2s_casc_p_c2_0.pl iovdd sg13_hv_pmos ad=2.04p pd=12.68u as=2.04p ps=12.68u w=6u l=4u
X150 iovdd d2s_cma_0.a pad iovdd sg13_hv_pmos ad=2.1312p pd=7.3u as=3.9294p ps=7.84u w=6.66u l=0.6u
X151 iovdd Clamp_P_M1_wiring_0.dabp Clamp_P_M1_wiring_0.dabp iovdd sg13_hv_pmos ad=2.1312p pd=7.3u as=3.9294p ps=7.84u w=6.66u l=0.6u
X152 iovss Clamp_N_M1_wiring_0.b pad iovss sg13_hv_nmos ad=1.408p pd=5.04u as=2.596p ps=5.58u w=4.4u l=1u
X153 iovdd d2s_block_0.bias_tree_n_f2_0.vbp d2s_block_0.d2s_rhigh_f2_0.sa_B iovdd sg13_hv_pmos ad=1.7p pd=10.68u as=1.7p ps=10.68u w=5u l=6u
X154 a_9918_32196# d2s_block_0.d2s_rhigh_f2_0.sa_C2 iovss rhigh l=12.65u w=0.5u
X155 d2s_block_0.d2s_casc_n_f2_0.x d2s_block_0.d2s_casc_n_f2_0.vbnc d2s_block_0.d2s_ab_n_f2_0.l1 iovss sg13_hv_nmos ad=5.1p pd=30.68u as=5.1p ps=30.68u w=15u l=3u
X156 pad d2s_cma_0.a iovdd iovdd sg13_hv_pmos ad=3.9294p pd=7.84u as=2.1312p ps=7.3u w=6.66u l=0.6u
X157 pad Clamp_N_M1_wiring_0.b iovss iovss sg13_hv_nmos ad=2.596p pd=5.58u as=1.408p ps=5.04u w=4.4u l=1u
X158 pad Clamp_N_M1_wiring_0.b iovss iovss sg13_hv_nmos ad=2.596p pd=5.58u as=1.408p ps=5.04u w=4.4u l=1u
X159 d2s_block_0.d2s_casc_n_f2_0.y vref d2s_block_0.d2s_rhigh_f2_0.sa_B d2s_block_0.d2s_rhigh_f2_0.sa_B sg13_hv_pmos ad=1.9p pd=10.38u as=3.4p ps=20.68u w=10u l=1u
X160 d2s_block_0.d2s_sp2k_f2_1.core iovdd dpantenna l=0.64u w=4.98u
X161 iovdd d2s_cma_0.a pad iovdd sg13_hv_pmos ad=2.1312p pd=7.3u as=3.9294p ps=7.84u w=6.66u l=0.6u
X162 d2s_block_0.d2s_ab_n_f2_0.l1 d2s_block_0.d2s_casc_n_f2_0.vbnc d2s_block_0.d2s_casc_n_f2_0.x iovss sg13_hv_nmos ad=5.1p pd=30.68u as=5.1p ps=30.68u w=15u l=3u
X163 iovdd d2s_cma_0.a pad iovdd sg13_hv_pmos ad=2.1312p pd=7.3u as=3.9294p ps=7.84u w=6.66u l=0.6u
X164 iovss Clamp_N_M1_wiring_0.b pad iovss sg13_hv_nmos ad=1.408p pd=5.04u as=2.596p ps=5.58u w=4.4u l=1u
X165 d2s_block_0.d2s_rhigh_f2_0.sb_B d2s_block_0.bias_tree_n_f2_0.vbp iovdd iovdd sg13_hv_pmos ad=1.7p pd=10.68u as=1.7p ps=10.68u w=5u l=6u
X166 d2s_block_0.d2s_casc_p_c2_0.pr d2s_block_0.d2s_ab_n_f2_0.l2 iovdd iovdd sg13_hv_pmos ad=2.04p pd=12.68u as=2.04p ps=12.68u w=6u l=4u
X167 iovss Clamp_N_M1_wiring_0.b pad iovss sg13_hv_nmos ad=1.408p pd=5.04u as=2.596p ps=5.58u w=4.4u l=1u
X168 pad d2s_cma_0.a iovdd iovdd sg13_hv_pmos ad=3.9294p pd=7.84u as=3.1302p ps=14.26u w=6.66u l=0.6u
X169 Clamp_N_M1_wiring_0.dabn Clamp_N_M1_wiring_0.dabn iovss iovss sg13_hv_nmos ad=2.596p pd=5.58u as=1.408p ps=5.04u w=4.4u l=1u
X170 iovdd d2s_cma_0.a pad iovdd sg13_hv_pmos ad=2.1312p pd=7.3u as=3.9294p ps=7.84u w=6.66u l=0.6u
X171 d2s_block_0.d2s_casc_n_f2_0.x d2s_block_0.sinks_6x6_f2_0.vbn iovss iovss sg13_hv_nmos ad=2.04p pd=12.68u as=2.04p ps=12.68u w=6u l=6u
X172 a_10734_32196# a_10326_29580# iovss rhigh l=12.65u w=0.5u
X173 d2s_block_0.d2s_rhigh_f2_0.sb_B vinn d2s_block_0.d2s_casc_n_f2_0.x d2s_block_0.d2s_rhigh_f2_0.sb_B sg13_hv_pmos ad=3.4p pd=20.68u as=1.9p ps=10.38u w=10u l=1u
X174 pad d2s_cma_0.a iovdd iovdd sg13_hv_pmos ad=3.9294p pd=7.84u as=2.1312p ps=7.3u w=6.66u l=0.6u
X175 iovdd d2s_block_0.bias_tree_n_f2_0.vbp d2s_block_0.d2s_casc_n_f2_0.vbnc iovdd sg13_hv_pmos ad=0.68p pd=4.68u as=0.68p ps=4.68u w=2u l=6u
X176 a_9646_32196# a_10326_29580# iovss rhigh l=12.65u w=0.5u
X177 pad d2s_cma_0.a iovdd iovdd sg13_hv_pmos ad=3.9294p pd=7.84u as=2.1312p ps=7.3u w=6.66u l=0.6u
X178 iovdd d2s_block_0.d2s_ab_n_f2_0.l2 d2s_block_0.d2s_casc_p_c2_0.pl iovdd sg13_hv_pmos ad=2.04p pd=12.68u as=2.04p ps=12.68u w=6u l=4u
X179 d2s_block_0.d2s_casc_p_c2_0.pl d2s_block_0.bias_tree_n_f2_0.vbpc d2s_block_0.d2s_ab_n_f2_0.l2 iovdd sg13_hv_pmos ad=5.1p pd=30.68u as=5.1p ps=30.68u w=15u l=3u
X180 iovss d2s_block_0.sinks_6x6_f2_0.vbn d2s_block_0.d2s_casc_n_f2_0.x iovss sg13_hv_nmos ad=2.04p pd=12.68u as=2.04p ps=12.68u w=6u l=6u
X181 pad Clamp_N_M1_wiring_0.b iovss iovss sg13_hv_nmos ad=2.596p pd=5.58u as=1.408p ps=5.04u w=4.4u l=1u
X182 iovdd d2s_block_0.bias_tree_n_f2_0.vbp iovdd iovdd sg13_hv_pmos ad=1.7p pd=10.68u as=0 ps=0 w=5u l=6u
X183 iovss d2s_block_0.sinks_6x6_f2_0.vbn d2s_block_0.sinks_6x6_f2_0.vbn iovss sg13_hv_nmos ad=2.04p pd=12.68u as=2.04p ps=12.68u w=6u l=6u
X184 d2s_block_0.d2s_ab_n_f2_0.vabn en_3v3_b iovss iovss sg13_hv_nmos ad=0.34p pd=2.68u as=0.34p ps=2.68u w=1u l=0.45u
X185 iovdd d2s_cma_0.a pad iovdd sg13_hv_pmos ad=2.1312p pd=7.3u as=3.9294p ps=7.84u w=6.66u l=0.6u
X186 pad d2s_cma_0.a iovdd iovdd sg13_hv_pmos ad=3.9294p pd=7.84u as=2.1312p ps=7.3u w=6.66u l=0.6u
X187 d2s_block_0.bias_tree_n_f2_0.ni d2s_block_0.bias_tree_n_f2_0.ni d2s_block_0.bias_tree_n_f2_0.ni iovss sg13_hv_nmos ad=0.816p pd=5.48u as=8.86665p ps=64.93u w=2.4u l=6u
X188 d2s_block_0.d2s_casc_p_c2_0.pr d2s_block_0.d2s_ab_n_f2_0.l2 iovdd iovdd sg13_hv_pmos ad=2.04p pd=12.68u as=2.04p ps=12.68u w=6u l=4u
X189 iovss Clamp_N_M1_wiring_0.b pad iovss sg13_hv_nmos ad=1.408p pd=5.04u as=2.596p ps=5.58u w=4.4u l=1u
X190 pad d2s_cma_0.a iovdd iovdd sg13_hv_pmos ad=3.9294p pd=7.84u as=2.1312p ps=7.3u w=6.66u l=0.6u
X191 iovdd iovdd iovdd iovdd sg13_hv_pmos ad=1.9p pd=10.38u as=0 ps=0 w=10u l=1u
X192 d2s_block_0.d2s_casc_n_f2_0.y d2s_block_0.d2s_casc_n_f2_0.vbnc Clamp_N_M1_wiring_0.b iovss sg13_hv_nmos ad=5.1p pd=30.68u as=5.1p ps=30.68u w=15u l=3u
X193 pad Clamp_N_M1_wiring_0.b iovss iovss sg13_hv_nmos ad=2.596p pd=5.58u as=1.408p ps=5.04u w=4.4u l=1u
X194 iovdd d2s_block_0.bias_tree_n_f2_0.vbp d2s_block_0.d2s_rhigh_f2_0.sb_C2 iovdd sg13_hv_pmos ad=1.7p pd=10.68u as=1.7p ps=10.68u w=5u l=6u
X195 a_9646_32196# d2s_block_0.d2s_rhigh_f2_0.sa_B iovss rhigh l=12.65u w=0.5u
X196 iovdd d2s_cma_0.a pad iovdd sg13_hv_pmos ad=2.1312p pd=7.3u as=3.9294p ps=7.84u w=6.66u l=0.6u
X197 pad d2s_cma_0.a iovdd iovdd sg13_hv_pmos ad=3.9294p pd=7.84u as=2.1312p ps=7.3u w=6.66u l=0.6u
X198 iovss Clamp_N_M1_wiring_0.b pad iovss sg13_hv_nmos ad=1.408p pd=5.04u as=2.596p ps=5.58u w=4.4u l=1u
X199 iovdd d2s_block_0.d2s_ab_n_f2_0.l2 iovdd iovdd sg13_hv_pmos ad=0.34p pd=2.68u as=0 ps=0 w=1u l=4u
X200 iovdd d2s_cma_0.a pad iovdd sg13_hv_pmos ad=2.1312p pd=7.3u as=3.9294p ps=7.84u w=6.66u l=0.6u
X201 Clamp_P_M1_wiring_0.dabp iovdd iovdd iovdd sg13_hv_pmos ad=3.9294p pd=7.84u as=2.1312p ps=7.3u w=6.66u l=0.6u
X202 iovss Clamp_N_M1_wiring_0.b pad iovss sg13_hv_nmos ad=1.408p pd=5.04u as=2.596p ps=5.58u w=4.4u l=1u
X203 d2s_block_0.d2s_casc_n_f2_0.x vref d2s_block_0.d2s_rhigh_f2_0.sb_A d2s_block_0.d2s_rhigh_f2_0.sb_A sg13_hv_pmos ad=1.9p pd=10.38u as=3.4p ps=20.68u w=10u l=1u
X204 iovdd d2s_cma_0.a pad iovdd sg13_hv_pmos ad=2.1312p pd=7.3u as=3.9294p ps=7.84u w=6.66u l=0.6u
X205 iovdd d2s_cma_0.a pad iovdd sg13_hv_pmos ad=2.1312p pd=7.3u as=3.9294p ps=7.84u w=6.66u l=0.6u
X206 d2s_block_0.d2s_rhigh_f2_0.sb_C2 pad d2s_block_0.d2s_casc_n_f2_0.x d2s_block_0.d2s_rhigh_f2_0.sb_C2 sg13_hv_pmos ad=3.4p pd=20.68u as=1.9p ps=10.38u w=10u l=1u
X207 pad Clamp_N_M1_wiring_0.b iovss iovss sg13_hv_nmos ad=2.596p pd=5.58u as=1.408p ps=5.04u w=4.4u l=1u
X208 iovss pad dantenna l=1.26u w=67.6u
X209 iovss d2s_block_0.d2s_sp2k_f2_0.core dantenna l=3.1u w=0.64u
X210 pad d2s_cma_0.a iovdd iovdd sg13_hv_pmos ad=3.9294p pd=7.84u as=2.1312p ps=7.3u w=6.66u l=0.6u
X211 pad Clamp_N_M1_wiring_0.b iovss iovss sg13_hv_nmos ad=2.596p pd=5.58u as=1.408p ps=5.04u w=4.4u l=1u
X212 iovss d2s_block_0.bias_tree_n_f2_0.ni d2s_block_0.bias_tree_n_f2_0.vabp iovss sg13_hv_nmos ad=2.04p pd=12.68u as=2.04p ps=12.68u w=6u l=6u
X213 a_10870_32196# a_10190_29580# iovss rhigh l=12.65u w=0.5u
X214 d2s_block_0.d2s_casc_n_f2_0.vbnc d2s_block_0.d2s_casc_n_f2_0.vbnc d2s_block_0.d2s_casc_n_f2_0.vbnc iovss sg13_hv_nmos ad=0.68p pd=4.68u as=0 ps=0 w=2u l=3u
X215 Clamp_N_M1_wiring_0.dabn d2s_block_0.d2s_ab_n_f2_0.vabn d2s_block_0.d2s_ab_n_f2_0.vabn iovss sg13_hv_nmos ad=1.496p pd=9.48u as=1.496p ps=9.48u w=4.4u l=1u
X216 iovdd d2s_cma_0.a pad iovdd sg13_hv_pmos ad=2.1312p pd=7.3u as=3.9294p ps=7.84u w=6.66u l=0.6u
X217 a_9510_32196# a_10462_29580# iovss rhigh l=12.65u w=0.5u
X218 iovss Clamp_N_M1_wiring_0.b pad iovss sg13_hv_nmos ad=1.408p pd=5.04u as=2.596p ps=5.58u w=4.4u l=1u
X219 pad d2s_cma_0.a iovdd iovdd sg13_hv_pmos ad=3.9294p pd=7.84u as=2.1312p ps=7.3u w=6.66u l=0.6u
X220 a_9918_32196# a_10054_29580# iovss rhigh l=12.65u w=0.5u
X221 d2s_block_0.sinks_6x6_f2_0.vbn d2s_block_0.sinks_6x6_f2_0.vbn d2s_block_0.sinks_6x6_f2_0.vbn iovss sg13_hv_nmos ad=0.68p pd=4.68u as=0 ps=0 w=2u l=6u
X222 iovdd d2s_block_0.d2s_ab_n_f2_0.l2 iovdd iovdd sg13_hv_pmos ad=0.34p pd=2.68u as=0 ps=0 w=1u l=4u
X223 iovss Clamp_N_M1_wiring_0.b pad iovss sg13_hv_nmos ad=1.408p pd=5.04u as=2.596p ps=5.58u w=4.4u l=1u
X224 pad d2s_cma_0.a iovdd iovdd sg13_hv_pmos ad=3.9294p pd=7.84u as=2.1312p ps=7.3u w=6.66u l=0.6u
X225 pad Clamp_N_M1_wiring_0.b iovss iovss sg13_hv_nmos ad=3.256p pd=10.28u as=1.408p ps=5.04u w=4.4u l=1u
X226 pad Clamp_N_M1_wiring_0.b iovss iovss sg13_hv_nmos ad=2.596p pd=5.58u as=1.408p ps=5.04u w=4.4u l=1u
X227 pad d2s_cma_0.a iovdd iovdd sg13_hv_pmos ad=3.9294p pd=7.84u as=2.1312p ps=7.3u w=6.66u l=0.6u
X228 d2s_block_0.d2s_casc_n_f2_0.x d2s_block_0.sinks_6x6_f2_0.vbn iovss iovss sg13_hv_nmos ad=2.04p pd=12.68u as=2.04p ps=12.68u w=6u l=6u
X229 iovdd d2s_block_0.bias_tree_n_f2_0.vbp d2s_block_0.d2s_rhigh_f2_0.sb_C1 iovdd sg13_hv_pmos ad=1.7p pd=10.68u as=1.7p ps=10.68u w=5u l=6u
X230 iovdd iovdd iovdd iovdd sg13_hv_pmos ad=1.9p pd=10.38u as=0 ps=0 w=10u l=1u
X231 d2s_block_0.d2s_casc_n_f2_0.y d2s_block_0.sinks_6x6_f2_0.vbn iovss iovss sg13_hv_nmos ad=2.04p pd=12.68u as=2.04p ps=12.68u w=6u l=6u
X232 pad d2s_cma_0.a iovdd iovdd sg13_hv_pmos ad=3.9294p pd=7.84u as=2.1312p ps=7.3u w=6.66u l=0.6u
X233 pad d2s_cma_0.a iovdd iovdd sg13_hv_pmos ad=3.9294p pd=7.84u as=2.1312p ps=7.3u w=6.66u l=0.6u
X234 iovdd iovdd iovdd iovdd sg13_hv_pmos ad=2.2644p pd=14u as=0 ps=0 w=6.66u l=0.6u
X235 iovdd d2s_cma_0.a pad iovdd sg13_hv_pmos ad=2.1312p pd=7.3u as=3.9294p ps=7.84u w=6.66u l=0.6u
X236 iovdd d2s_block_0.bias_tree_n_f2_0.vbp d2s_block_0.bias_tree_n_f2_0.vbp iovdd sg13_hv_pmos ad=1.7p pd=10.68u as=1.7p ps=10.68u w=5u l=6u
X237 a_9782_32196# d2s_block_0.d2s_rhigh_f2_0.sa_C1 iovss rhigh l=12.65u w=0.5u
X238 pad d2s_cma_0.a iovdd iovdd sg13_hv_pmos ad=3.9294p pd=7.84u as=2.1312p ps=7.3u w=6.66u l=0.6u
X239 Clamp_P_M1_wiring_0.dabp iovdd iovdd iovdd sg13_hv_pmos ad=3.9294p pd=7.84u as=2.1312p ps=7.3u w=6.66u l=0.6u
X240 iovss iovss iovss rhigh l=12.65u w=0.5u
X241 iovdd iovdd iovdd iovdd sg13_hv_pmos ad=3.4p pd=20.68u as=0 ps=0 w=10u l=1u
X242 iovdd d2s_cma_0.a pad iovdd sg13_hv_pmos ad=2.1312p pd=7.3u as=3.9294p ps=7.84u w=6.66u l=0.6u
X243 iovdd d2s_cma_0.a pad iovdd sg13_hv_pmos ad=2.1312p pd=7.3u as=3.9294p ps=7.84u w=6.66u l=0.6u
X244 iovdd d2s_cma_0.a pad iovdd sg13_hv_pmos ad=2.1312p pd=7.3u as=3.9294p ps=7.84u w=6.66u l=0.6u
X245 d2s_block_0.d2s_casc_n_f2_0.vbnc d2s_block_0.d2s_casc_n_f2_0.vbnc d2s_block_0.d2s_casc_n_f2_0.vbnc iovss sg13_hv_nmos ad=0.68p pd=4.68u as=0 ps=0 w=2u l=3u
X246 iovss d2s_block_0.sinks_6x6_f2_0.vbn d2s_block_0.d2s_casc_n_f2_0.y iovss sg13_hv_nmos ad=2.04p pd=12.68u as=2.04p ps=12.68u w=6u l=6u
X247 pad d2s_cma_0.a iovdd iovdd sg13_hv_pmos ad=3.9294p pd=7.84u as=2.1312p ps=7.3u w=6.66u l=0.6u
X248 pad Clamp_N_M1_wiring_0.b iovss iovss sg13_hv_nmos ad=2.596p pd=5.58u as=1.408p ps=5.04u w=4.4u l=1u
X249 pad Clamp_N_M1_wiring_0.b iovss iovss sg13_hv_nmos ad=2.596p pd=5.58u as=1.408p ps=5.04u w=4.4u l=1u
X250 iovdd d2s_cma_0.a pad iovdd sg13_hv_pmos ad=2.1312p pd=7.3u as=3.9294p ps=7.84u w=6.66u l=0.6u
X251 pad Clamp_N_M1_wiring_0.b iovss iovss sg13_hv_nmos ad=2.596p pd=5.58u as=1.408p ps=5.04u w=4.4u l=1u
X252 iovss iovss iovss rhigh l=12.65u w=0.5u
X253 d2s_cma_0.a d2s_block_0.bias_tree_n_f2_0.vbpc d2s_block_0.d2s_casc_p_c2_0.pr iovdd sg13_hv_pmos ad=5.1p pd=30.68u as=5.1p ps=30.68u w=15u l=3u
X254 pad d2s_cma_0.a iovdd iovdd sg13_hv_pmos ad=3.9294p pd=7.84u as=2.1312p ps=7.3u w=6.66u l=0.6u
X255 a_10870_32196# d2s_block_0.d2s_rhigh_f2_0.sb_C1 iovss rhigh l=12.65u w=0.5u
X256 pad d2s_cma_0.a iovdd iovdd sg13_hv_pmos ad=3.9294p pd=7.84u as=2.1312p ps=7.3u w=6.66u l=0.6u
X257 iovdd d2s_cma_0.a pad iovdd sg13_hv_pmos ad=2.1312p pd=7.3u as=3.9294p ps=7.84u w=6.66u l=0.6u
X258 d2s_block_0.d2s_casc_n_f2_0.x pad d2s_block_0.d2s_rhigh_f2_0.sb_C1 d2s_block_0.d2s_rhigh_f2_0.sb_C1 sg13_hv_pmos ad=1.9p pd=10.38u as=3.4p ps=20.68u w=10u l=1u
X259 d2s_block_0.d2s_rhigh_f2_0.sa_C1 vref d2s_block_0.d2s_casc_n_f2_0.y d2s_block_0.d2s_rhigh_f2_0.sa_C1 sg13_hv_pmos ad=3.4p pd=20.68u as=1.9p ps=10.38u w=10u l=1u
X260 iovss Clamp_N_M1_wiring_0.b pad iovss sg13_hv_nmos ad=1.408p pd=5.04u as=2.596p ps=5.58u w=4.4u l=1u
X261 iovss Clamp_N_M1_wiring_0.b pad iovss sg13_hv_nmos ad=1.408p pd=5.04u as=2.596p ps=5.58u w=4.4u l=1u
X262 iovss Clamp_N_M1_wiring_0.b pad iovss sg13_hv_nmos ad=1.408p pd=5.04u as=2.596p ps=5.58u w=4.4u l=1u
X263 a_9782_32196# a_10190_29580# iovss rhigh l=12.65u w=0.5u
X264 pad d2s_cma_0.a iovdd iovdd sg13_hv_pmos ad=3.9294p pd=7.84u as=2.1312p ps=7.3u w=6.66u l=0.6u
X265 pad Clamp_N_M1_wiring_0.b iovss iovss sg13_hv_nmos ad=2.596p pd=5.58u as=1.408p ps=5.04u w=4.4u l=1u
X266 d2s_block_0.bias_tree_n_f2_0.vabp en_3v3 iovdd iovdd sg13_hv_pmos ad=0.34p pd=2.68u as=0.34p ps=2.68u w=1u l=0.45u
X267 pad d2s_cma_0.a iovdd iovdd sg13_hv_pmos ad=3.9294p pd=7.84u as=2.1312p ps=7.3u w=6.66u l=0.6u
X268 pad Clamp_N_M1_wiring_0.b iovss iovss sg13_hv_nmos ad=2.596p pd=5.58u as=1.408p ps=5.04u w=4.4u l=1u
X269 pad d2s_cma_0.a iovdd iovdd sg13_hv_pmos ad=3.9294p pd=7.84u as=2.1312p ps=7.3u w=6.66u l=0.6u
X270 iovdd d2s_block_0.bias_tree_n_f2_0.vbp d2s_block_0.d2s_rhigh_f2_0.sa_A iovdd sg13_hv_pmos ad=1.7p pd=10.68u as=1.7p ps=10.68u w=5u l=6u
X271 Clamp_N_M1_wiring_0.b d2s_block_0.bias_tree_n_f2_0.vabp d2s_cma_0.a iovdd sg13_hv_pmos ad=2.2644p pd=14u as=2.2644p ps=14u w=6.66u l=0.6u
X272 pad d2s_cma_0.a iovdd iovdd sg13_hv_pmos ad=3.9294p pd=7.84u as=2.1312p ps=7.3u w=6.66u l=0.6u
X273 iovss Clamp_N_M1_wiring_0.b pad iovss sg13_hv_nmos ad=1.408p pd=5.04u as=2.596p ps=5.58u w=4.4u l=1u
X274 iovdd d2s_cma_0.a pad iovdd sg13_hv_pmos ad=2.1312p pd=7.3u as=3.9294p ps=7.84u w=6.66u l=0.6u
X275 iovss Clamp_N_M1_wiring_0.b pad iovss sg13_hv_nmos ad=1.408p pd=5.04u as=2.596p ps=5.58u w=4.4u l=1u
X276 iovss Clamp_N_M1_wiring_0.dabn Clamp_N_M1_wiring_0.dabn iovss sg13_hv_nmos ad=1.408p pd=5.04u as=2.596p ps=5.58u w=4.4u l=1u
X277 pad Clamp_N_M1_wiring_0.b iovss iovss sg13_hv_nmos ad=2.596p pd=5.58u as=2.068p ps=9.74u w=4.4u l=1u
X278 iovdd iovdd iovdd iovdd sg13_hv_pmos ad=1.9p pd=10.38u as=0 ps=0 w=10u l=1u
X279 iovdd d2s_cma_0.a pad iovdd sg13_hv_pmos ad=2.1312p pd=7.3u as=3.9294p ps=7.84u w=6.66u l=0.6u
X280 pad Clamp_N_M1_wiring_0.b iovss iovss sg13_hv_nmos ad=2.596p pd=5.58u as=1.408p ps=5.04u w=4.4u l=1u
X281 pad Clamp_N_M1_wiring_0.b iovss iovss sg13_hv_nmos ad=2.596p pd=5.58u as=1.408p ps=5.04u w=4.4u l=1u
X282 pad d2s_cma_0.a iovdd iovdd sg13_hv_pmos ad=4.9284p pd=14.8u as=2.1312p ps=7.3u w=6.66u l=0.6u
X283 iovdd d2s_cma_0.a pad iovdd sg13_hv_pmos ad=2.1312p pd=7.3u as=3.9294p ps=7.84u w=6.66u l=0.6u
X284 d2s_block_0.d2s_casc_n_f2_0.x d2s_block_0.sinks_6x6_f2_0.vbn iovss iovss sg13_hv_nmos ad=2.04p pd=12.68u as=2.04p ps=12.68u w=6u l=6u
X285 pad d2s_cma_0.a iovdd iovdd sg13_hv_pmos ad=3.9294p pd=7.84u as=2.1312p ps=7.3u w=6.66u l=0.6u
X286 iovss Clamp_N_M1_wiring_0.b pad iovss sg13_hv_nmos ad=1.408p pd=5.04u as=2.596p ps=5.58u w=4.4u l=1u
X287 iovdd d2s_cma_0.a pad iovdd sg13_hv_pmos ad=2.1312p pd=7.3u as=3.9294p ps=7.84u w=6.66u l=0.6u
X288 iovss Clamp_N_M1_wiring_0.b pad iovss sg13_hv_nmos ad=1.408p pd=5.04u as=2.596p ps=5.58u w=4.4u l=1u
X289 iovdd iovdd iovdd iovdd sg13_hv_pmos ad=3.4p pd=20.68u as=0 ps=0 w=10u l=1u
X290 iovss iovss iovss iovss sg13_hv_nmos ad=1.496p pd=9.48u as=0 ps=0 w=4.4u l=1u
X291 iovdd d2s_cma_0.a pad iovdd sg13_hv_pmos ad=2.1312p pd=7.3u as=3.9294p ps=7.84u w=6.66u l=0.6u
X292 pad Clamp_N_M1_wiring_0.b iovss iovss sg13_hv_nmos ad=2.596p pd=5.58u as=1.408p ps=5.04u w=4.4u l=1u
C0 d2s_block_0.d2s_casc_n_f2_0.y d2s_block_0.bias_tree_n_f2_0.vbpc 0.35504f
C1 a_10598_32196# a_11550_29666# 0.02713f
C2 a_10870_29666# d2s_block_0.d2s_rhigh_f2_0.sb_C2 0.02119f
C3 iovdd Clamp_P_M1_wiring_0.dabp 6.67031f
C4 d2s_block_0.d2s_rhigh_f2_0.sb_B d2s_block_0.d2s_rhigh_f2_0.sa_B 0.17725f
C5 d2s_block_0.bias_tree_n_f2_0.vabp d2s_block_0.sinks_6x6_f2_0.vbn 1.11797f
C6 d2s_block_0.d2s_casc_n_f2_0.y d2s_block_0.bias_tree_n_f2_0.vbp 0.09483f
C7 d2s_block_0.d2s_rhigh_f2_0.sb_C1 vref 0.01473f
C8 a_9374_29666# vdd 0.01009f
C9 a_9646_29666# a_9510_29666# 0.63642f
C10 d2s_block_0.d2s_rhigh_f2_0.sa_A d2s_block_0.d2s_rhigh_f2_0.sb_C1 0.06509f
C11 a_11006_32196# vdd 0.11929f
C12 en_3v3 d2s_block_0.sinks_6x6_f2_0.vbn 0.03788f
C13 Clamp_P_M1_wiring_0.dabp d2s_block_0.bias_tree_n_f2_0.vabp 0.37452f
C14 d2s_block_0.d2s_casc_n_f2_0.y vdd 0.14981f
C15 a_9646_32196# a_9510_32196# 0.78325f
C16 a_11278_29666# d2s_block_0.d2s_rhigh_f2_0.sb_B 0.05309f
C17 en_3v3_b d2s_block_0.bias_tree_n_f2_0.vbpc 0.01576f
C18 d2s_block_0.d2s_rhigh_f2_0.sa_C2 vinn 0.1108f
C19 a_10190_29666# d2s_block_0.d2s_rhigh_f2_0.sb_C1 0.02562f
C20 d2s_cma_0.a Clamp_N_M1_wiring_0.dabn 0.65752f
C21 a_11006_29666# d2s_block_0.d2s_rhigh_f2_0.sb_B 0.04376f
C22 a_10054_29666# d2s_block_0.d2s_rhigh_f2_0.sb_B 0.04313f
C23 en_3v3_b d2s_block_0.bias_tree_n_f2_0.vbp 0.04303f
C24 d2s_block_0.d2s_casc_n_f2_0.x d2s_block_0.d2s_ab_n_f2_0.vabn 0.59568f
C25 d2s_block_0.d2s_ab_n_f2_0.vabn d2s_block_0.d2s_casc_n_f2_0.vbnc 0.35232f
C26 d2s_block_0.d2s_ab_n_f2_0.l1 Clamp_P_M1_wiring_0.dabp 0.09453f
C27 d2s_block_0.d2s_rhigh_f2_0.sb_C1 a_9510_29666# 0.02554f
C28 a_10326_29666# a_9646_32196# 0.02719f
C29 d2s_block_0.d2s_rhigh_f2_0.sb_C1 a_11142_29666# 0.03293f
C30 en_3v3_b vdd 1.59368f
C31 d2s_block_0.d2s_rhigh_f2_0.sa_C2 d2s_block_0.d2s_rhigh_f2_0.sb_C2 0.08696f
C32 vinp d2s_block_0.d2s_rhigh_f2_0.sa_B 0.14038f
C33 d2s_block_0.d2s_casc_n_f2_0.x d2s_block_0.d2s_rhigh_f2_0.sa_B 0.62706f
C34 d2s_block_0.d2s_casc_n_f2_0.vbnc d2s_block_0.d2s_rhigh_f2_0.sa_B 0.29163f
C35 d2s_block_0.d2s_casc_n_f2_0.y en_3v3_b 1.29065f
C36 a_9782_32196# a_9646_32196# 0.55763f
C37 Clamp_N_M1_wiring_0.b d2s_block_0.d2s_sp2k_f2_0.core 29.3545f
C38 a_10326_29580# d2s_block_0.d2s_rhigh_f2_0.sb_C2 0.12303f
C39 d2s_block_0.d2s_rhigh_f2_0.sa_C1 vinn 0.11198f
C40 pad d2s_block_0.d2s_rhigh_f2_0.sb_B 0.6063f
C41 a_9510_32196# vdd 0.29163f
C42 vdd a_9782_29666# 0.01326f
C43 a_11686_29666# en_3v3 0.02805f
C44 a_10598_29666# a_10462_29666# 0.63642f
C45 iovdd d2s_block_0.d2s_ab_n_f2_0.vabn 2.84271f
C46 Clamp_N_M1_wiring_0.b d2s_block_0.d2s_ab_n_f2_0.l2 0.46037f
C47 a_10462_29666# vdd 0.01326f
C48 a_10190_29580# d2s_block_0.d2s_rhigh_f2_0.sb_C2 0.12128f
C49 pad d2s_cma_0.a 48.1271f
C50 d2s_block_0.d2s_rhigh_f2_0.sb_A d2s_block_0.d2s_rhigh_f2_0.sb_B 0.23114f
C51 a_812_18030# pad 0.08365f
C52 d2s_block_0.d2s_rhigh_f2_0.sa_C1 d2s_block_0.d2s_rhigh_f2_0.sb_C2 0.09016f
C53 d2s_block_0.bias_tree_n_f2_0.vabp d2s_block_0.d2s_ab_n_f2_0.vabn 0.03145f
C54 a_10326_29666# vdd 0.01326f
C55 a_11550_29666# d2s_block_0.d2s_rhigh_f2_0.sb_A 0.02699f
C56 d2s_block_0.d2s_ab_n_f2_0.vabn en_3v3 7.29654f
C57 d2s_block_0.d2s_rhigh_f2_0.sb_C1 a_10870_29666# 0.02617f
C58 iovdd d2s_block_0.d2s_rhigh_f2_0.sa_B 0.8697f
C59 d2s_block_0.d2s_rhigh_f2_0.sa_C1 d2s_block_0.d2s_rhigh_f2_0.sa_C2 7.08342f
C60 a_9646_29666# d2s_block_0.d2s_rhigh_f2_0.sb_C2 0.0209f
C61 iref d2s_block_0.d2s_rhigh_f2_0.sa_C2 0.0852f
C62 vref d2s_block_0.d2s_rhigh_f2_0.sa_B 2.91863f
C63 d2s_block_0.d2s_rhigh_f2_0.sa_A d2s_block_0.d2s_rhigh_f2_0.sa_B 1.53969f
C64 a_10190_29580# a_10326_29580# 0.55763f
C65 a_9646_29666# d2s_block_0.d2s_rhigh_f2_0.sa_C2 0.04605f
C66 a_9782_32196# vdd 0.18987f
C67 a_10870_32196# a_11278_29666# 0.02728f
C68 d2s_block_0.d2s_casc_p_c2_0.pl Clamp_N_M1_wiring_0.b 0.1393f
C69 d2s_block_0.d2s_ab_n_f2_0.l1 d2s_block_0.d2s_ab_n_f2_0.vabn 0.56759f
C70 a_11414_29666# d2s_block_0.d2s_ab_n_f2_0.vabn 0.0523f
C71 d2s_block_0.bias_tree_n_f2_0.vbpc d2s_block_0.d2s_rhigh_f2_0.sb_B 0.02864f
C72 iovdd Clamp_N_M1_wiring_0.dabn 5.84298f
C73 a_9918_29666# a_10054_29666# 0.63642f
C74 pad vinp 4.87783f
C75 d2s_block_0.d2s_ab_n_f2_0.vabn a_11142_29666# 0.02664f
C76 d2s_block_0.bias_tree_n_f2_0.vbp d2s_block_0.d2s_rhigh_f2_0.sb_B 0.39285f
C77 d2s_block_0.d2s_casc_n_f2_0.x pad 1.52067f
C78 d2s_block_0.bias_tree_n_f2_0.vbpc d2s_cma_0.a 6.12127f
C79 a_10598_29666# d2s_block_0.d2s_rhigh_f2_0.sb_B 0.04323f
C80 Clamp_N_M1_wiring_0.b Clamp_P_M1_wiring_0.dabp 0.07973f
C81 d2s_block_0.d2s_rhigh_f2_0.sb_B vdd 0.77713f
C82 d2s_block_0.d2s_rhigh_f2_0.sb_C1 d2s_block_0.d2s_rhigh_f2_0.sb_C2 2.96153f
C83 d2s_block_0.d2s_casc_n_f2_0.x d2s_block_0.d2s_rhigh_f2_0.sb_A 0.97788f
C84 d2s_block_0.d2s_rhigh_f2_0.sb_B a_9374_29666# 0.0292f
C85 iref d2s_block_0.d2s_rhigh_f2_0.sa_C1 0.01252f
C86 d2s_block_0.sinks_6x6_f2_0.vbn d2s_block_0.d2s_rhigh_f2_0.sa_C2 1.24398f
C87 a_9510_29666# d2s_block_0.d2s_rhigh_f2_0.sa_B 0.04789f
C88 d2s_block_0.d2s_rhigh_f2_0.sb_A d2s_block_0.d2s_casc_n_f2_0.vbnc 0.15539f
C89 a_11550_29666# vdd 0.01326f
C90 d2s_block_0.d2s_rhigh_f2_0.sb_C1 d2s_block_0.d2s_rhigh_f2_0.sa_C2 0.05219f
C91 d2s_block_0.d2s_casc_n_f2_0.y d2s_block_0.d2s_rhigh_f2_0.sb_B 0.52521f
C92 a_9646_29666# d2s_block_0.d2s_rhigh_f2_0.sa_C1 0.08627f
C93 a_10462_29666# a_9510_32196# 0.02713f
C94 d2s_block_0.bias_tree_n_f2_0.ni iref 0.10634f
C95 d2s_block_0.d2s_ab_n_f2_0.l1 Clamp_N_M1_wiring_0.dabn 0.8559f
C96 d2s_block_0.d2s_sp2k_f2_0.core d2s_block_0.sinks_6x6_f2_0.vbn 0.0411f
C97 d2s_block_0.d2s_casc_p_c2_0.pl d2s_block_0.d2s_ab_n_f2_0.l2 2.28979f
C98 a_11278_29666# a_11414_29666# 0.63642f
C99 a_10190_29666# a_10054_29666# 0.63642f
C100 iovdd pad 0.13637p
C101 a_10326_29666# a_10462_29666# 0.63642f
C102 a_10734_29666# a_10870_29666# 0.63642f
C103 a_11278_29666# a_11142_29666# 0.63642f
C104 d2s_block_0.bias_tree_n_f2_0.vbpc vinp 0.01581f
C105 d2s_block_0.d2s_casc_n_f2_0.x d2s_block_0.bias_tree_n_f2_0.vbpc 0.35066f
C106 vref pad 0.28667f
C107 d2s_block_0.bias_tree_n_f2_0.vbpc d2s_block_0.d2s_casc_p_c2_0.pr 2.95522f
C108 d2s_block_0.d2s_ab_n_f2_0.vabn a_10870_29666# 0.01435f
C109 d2s_block_0.bias_tree_n_f2_0.vbpc d2s_block_0.d2s_casc_n_f2_0.vbnc 0.39211f
C110 iovdd d2s_block_0.d2s_rhigh_f2_0.sb_A 1.35344f
C111 d2s_block_0.d2s_rhigh_f2_0.sa_A pad 0.01838f
C112 a_11006_29666# a_11142_29666# 0.63642f
C113 d2s_block_0.d2s_rhigh_f2_0.sa_C1 d2s_block_0.sinks_6x6_f2_0.vbn 0.9803f
C114 iref d2s_block_0.sinks_6x6_f2_0.vbn 0.56722f
C115 d2s_block_0.bias_tree_n_f2_0.vbp d2s_block_0.d2s_casc_n_f2_0.vbnc 0.26597f
C116 d2s_block_0.d2s_rhigh_f2_0.sb_C1 d2s_block_0.d2s_rhigh_f2_0.sa_C1 0.01883f
C117 a_9782_32196# a_9782_29666# 0.02438f
C118 d2s_block_0.d2s_sp2k_f2_1.core Clamp_N_M1_wiring_0.dabn 0.08675f
C119 vref d2s_block_0.d2s_rhigh_f2_0.sb_A 2.68862f
C120 vinp vdd 1.38278f
C121 d2s_block_0.d2s_rhigh_f2_0.sa_A d2s_block_0.d2s_rhigh_f2_0.sb_A 0.0301f
C122 d2s_block_0.d2s_casc_n_f2_0.x vdd 0.11766f
C123 d2s_block_0.d2s_casc_n_f2_0.vbnc vdd 1.23326f
C124 d2s_block_0.bias_tree_n_f2_0.ni d2s_block_0.sinks_6x6_f2_0.vbn 0.01716f
C125 a_9646_29666# d2s_block_0.d2s_rhigh_f2_0.sb_C1 0.02555f
C126 a_9374_29666# d2s_block_0.d2s_casc_n_f2_0.vbnc 0.10381f
C127 d2s_block_0.d2s_casc_n_f2_0.y vinp 0.71522f
C128 d2s_block_0.d2s_casc_n_f2_0.y d2s_block_0.d2s_casc_n_f2_0.x 14.9543f
C129 d2s_block_0.d2s_casc_n_f2_0.y d2s_block_0.d2s_casc_p_c2_0.pr 0.06645f
C130 d2s_block_0.d2s_casc_n_f2_0.y d2s_block_0.d2s_casc_n_f2_0.vbnc 2.6787f
C131 iovdd a_15058_18030# 0.16084f
C132 a_10734_29666# d2s_block_0.d2s_rhigh_f2_0.sb_C2 0.02102f
C133 Clamp_N_M1_wiring_0.b d2s_block_0.d2s_ab_n_f2_0.vabn 0.32223f
C134 d2s_block_0.d2s_rhigh_f2_0.sb_B a_9782_29666# 0.04292f
C135 a_10462_29666# d2s_block_0.d2s_rhigh_f2_0.sb_B 0.04319f
C136 a_10734_32196# a_10734_29666# 0.02719f
C137 iovdd d2s_block_0.bias_tree_n_f2_0.vbpc 28.8714f
C138 a_10870_32196# vdd 0.18862f
C139 d2s_block_0.d2s_rhigh_f2_0.sa_B vinn 0.04693f
C140 a_9918_29666# vdd 0.01326f
C141 iovdd d2s_block_0.bias_tree_n_f2_0.vbp 52.5035f
C142 vref d2s_block_0.bias_tree_n_f2_0.vbpc 0.01701f
C143 a_10326_29666# d2s_block_0.d2s_rhigh_f2_0.sb_B 0.04316f
C144 d2s_block_0.d2s_ab_n_f2_0.vabn d2s_block_0.d2s_rhigh_f2_0.sa_C2 0.05927f
C145 d2s_block_0.d2s_rhigh_f2_0.sa_A d2s_block_0.bias_tree_n_f2_0.vbpc 0.02582f
C146 a_10870_32196# a_11006_32196# 0.33426f
C147 vref d2s_block_0.bias_tree_n_f2_0.vbp 0.41746f
C148 iovdd vdd 3.87859f
C149 a_10598_32196# a_10734_32196# 0.78325f
C150 a_11006_29666# a_10870_29666# 0.63642f
C151 d2s_block_0.d2s_rhigh_f2_0.sa_A d2s_block_0.bias_tree_n_f2_0.vbp 0.25372f
C152 d2s_block_0.d2s_sp2k_f2_1.core pad 6.30962f
C153 d2s_block_0.bias_tree_n_f2_0.vbpc en_3v3 0.06905f
C154 d2s_block_0.d2s_rhigh_f2_0.sa_B d2s_block_0.d2s_rhigh_f2_0.sb_C2 0.0974f
C155 en_3v3_b d2s_block_0.d2s_casc_n_f2_0.x 0.03622f
C156 vref vdd 1.49159f
C157 en_3v3_b d2s_block_0.d2s_casc_n_f2_0.vbnc 0.06336f
C158 d2s_block_0.d2s_rhigh_f2_0.sa_A vdd 0.08381f
C159 d2s_block_0.bias_tree_n_f2_0.vabp vdd 1.03501f
C160 d2s_block_0.bias_tree_n_f2_0.vbp en_3v3 0.2049f
C161 d2s_block_0.d2s_casc_n_f2_0.y iovdd 7.85214f
C162 d2s_block_0.d2s_rhigh_f2_0.sa_C2 d2s_block_0.d2s_rhigh_f2_0.sa_B 0.1563f
C163 d2s_block_0.d2s_rhigh_f2_0.sa_A a_9374_29666# 0.0292f
C164 en_3v3 vdd 1.73652f
C165 d2s_block_0.d2s_casc_n_f2_0.y vref 2.38694f
C166 d2s_block_0.d2s_casc_n_f2_0.y d2s_block_0.d2s_rhigh_f2_0.sa_A 0.92783f
C167 d2s_block_0.d2s_casc_n_f2_0.y d2s_block_0.bias_tree_n_f2_0.vabp 0.62468f
C168 Clamp_N_M1_wiring_0.b Clamp_N_M1_wiring_0.dabn 0.565f
C169 a_10054_29580# d2s_block_0.d2s_rhigh_f2_0.sb_C2 0.31811f
C170 d2s_block_0.d2s_ab_n_f2_0.vabn d2s_block_0.d2s_ab_n_f2_0.l2 0.24918f
C171 d2s_block_0.d2s_casc_n_f2_0.y en_3v3 0.02575f
C172 d2s_block_0.d2s_ab_n_f2_0.vabn d2s_block_0.d2s_rhigh_f2_0.sa_C1 0.86633f
C173 a_9510_32196# d2s_block_0.d2s_casc_n_f2_0.vbnc 0.21011f
C174 a_10190_29666# vdd 0.01326f
C175 d2s_block_0.d2s_casc_n_f2_0.vbnc a_9782_29666# 0.01214f
C176 a_10054_29580# d2s_block_0.d2s_rhigh_f2_0.sa_C2 0.19848f
C177 d2s_block_0.d2s_ab_n_f2_0.l1 vdd 0.01417f
C178 a_11006_29666# d2s_block_0.d2s_rhigh_f2_0.sb_C2 0.02172f
C179 a_10054_29666# d2s_block_0.d2s_rhigh_f2_0.sb_C2 0.0209f
C180 a_11414_29666# vdd 0.01326f
C181 a_9510_29666# vdd 0.01324f
C182 en_3v3_b iovdd 1.46452f
C183 a_11142_29666# vdd 0.01326f
C184 a_9510_29666# a_9374_29666# 0.63642f
C185 a_10054_29666# d2s_block_0.d2s_rhigh_f2_0.sa_C2 0.04588f
C186 a_11550_29666# d2s_block_0.d2s_rhigh_f2_0.sb_B 0.01861f
C187 d2s_block_0.d2s_ab_n_f2_0.l1 d2s_block_0.d2s_casc_n_f2_0.y 0.08525f
C188 d2s_block_0.d2s_rhigh_f2_0.sa_C1 d2s_block_0.d2s_rhigh_f2_0.sa_B 1.67372f
C189 en_3v3_b d2s_block_0.bias_tree_n_f2_0.vabp 1.09664f
C190 a_11142_29666# a_11006_32196# 0.02746f
C191 pad vinn 0.18905f
C192 a_9918_29666# a_9782_29666# 0.63642f
C193 en_3v3_b en_3v3 8.63296f
C194 a_9646_29666# d2s_block_0.d2s_rhigh_f2_0.sa_B 0.0538f
C195 a_10054_29580# a_10190_29580# 0.78325f
C196 d2s_block_0.d2s_rhigh_f2_0.sb_A vinn 0.10431f
C197 Clamp_N_M1_wiring_0.b pad 38.277f
C198 d2s_block_0.d2s_ab_n_f2_0.l2 Clamp_N_M1_wiring_0.dabn 0.07862f
C199 d2s_block_0.d2s_rhigh_f2_0.sb_C1 a_10734_29666# 0.02589f
C200 pad d2s_block_0.d2s_rhigh_f2_0.sb_C2 2.70034f
C201 d2s_block_0.d2s_ab_n_f2_0.vabn d2s_block_0.sinks_6x6_f2_0.vbn 0.36408f
C202 d2s_block_0.d2s_rhigh_f2_0.sb_A d2s_block_0.d2s_rhigh_f2_0.sb_C2 0.02061f
C203 vinp d2s_block_0.d2s_rhigh_f2_0.sb_B 0.09952f
C204 d2s_block_0.d2s_casc_n_f2_0.x d2s_block_0.d2s_rhigh_f2_0.sb_B 0.88986f
C205 d2s_block_0.d2s_rhigh_f2_0.sb_A d2s_block_0.d2s_rhigh_f2_0.sa_C2 0.44573f
C206 d2s_block_0.d2s_rhigh_f2_0.sb_B d2s_block_0.d2s_casc_n_f2_0.vbnc 0.03816f
C207 a_10870_29666# vdd 0.01326f
C208 d2s_block_0.d2s_rhigh_f2_0.sb_C1 d2s_block_0.d2s_rhigh_f2_0.sa_B 0.29986f
C209 d2s_cma_0.a d2s_block_0.d2s_casc_p_c2_0.pr 0.29884f
C210 d2s_block_0.bias_tree_n_f2_0.vbpc vinn 0.01581f
C211 pad d2s_block_0.d2s_sp2k_f2_0.core 7.04262f
C212 a_9510_29666# a_9510_32196# 0.02514f
C213 vinn vdd 1.10953f
C214 d2s_block_0.bias_tree_n_f2_0.vbpc d2s_block_0.d2s_rhigh_f2_0.sb_C2 0.02864f
C215 a_10054_29666# a_9918_32196# 0.02746f
C216 pad d2s_block_0.d2s_rhigh_f2_0.sa_C1 0.1114f
C217 a_9918_29666# d2s_block_0.d2s_rhigh_f2_0.sb_B 0.04304f
C218 a_10190_29666# a_10326_29666# 0.63642f
C219 d2s_block_0.bias_tree_n_f2_0.vbp d2s_block_0.d2s_rhigh_f2_0.sb_C2 0.23417f
C220 d2s_block_0.d2s_rhigh_f2_0.sb_C1 a_11278_29666# 0.04835f
C221 Clamp_P_M1_wiring_0.dabp Clamp_N_M1_wiring_0.dabn 1.20516f
C222 Clamp_N_M1_wiring_0.b vdd 0.01417f
C223 d2s_block_0.bias_tree_n_f2_0.vbpc d2s_block_0.d2s_rhigh_f2_0.sa_C2 2.5437f
C224 a_10598_29666# d2s_block_0.d2s_rhigh_f2_0.sb_C2 0.02096f
C225 d2s_block_0.d2s_casc_n_f2_0.y vinn 0.07839f
C226 d2s_block_0.d2s_rhigh_f2_0.sb_C1 a_11006_29666# 0.02689f
C227 d2s_block_0.d2s_rhigh_f2_0.sb_C1 a_10054_29666# 0.02561f
C228 iovdd d2s_block_0.d2s_rhigh_f2_0.sb_B 2.31968f
C229 d2s_block_0.d2s_rhigh_f2_0.sa_C1 d2s_block_0.d2s_rhigh_f2_0.sb_A 3.00544f
C230 d2s_block_0.d2s_rhigh_f2_0.sb_C2 vdd 0.0838f
C231 d2s_block_0.bias_tree_n_f2_0.vbp d2s_block_0.d2s_rhigh_f2_0.sa_C2 0.27689f
C232 a_11686_29666# d2s_block_0.d2s_ab_n_f2_0.vabn 0.12626f
C233 a_9374_29666# d2s_block_0.d2s_rhigh_f2_0.sb_C2 0.02455f
C234 vref d2s_block_0.d2s_rhigh_f2_0.sb_B 2.98966f
C235 iovdd d2s_cma_0.a 0.12278p
C236 a_10734_32196# vdd 0.24464f
C237 a_10598_29666# d2s_block_0.d2s_rhigh_f2_0.sa_C2 0.01215f
C238 d2s_block_0.d2s_rhigh_f2_0.sa_A d2s_block_0.d2s_rhigh_f2_0.sb_B 3.34743f
C239 d2s_block_0.d2s_casc_n_f2_0.y Clamp_N_M1_wiring_0.b 0.30126f
C240 d2s_block_0.d2s_rhigh_f2_0.sa_C2 vdd 1.26576f
C241 a_9782_32196# a_10190_29666# 0.02728f
C242 a_15058_18030# d2s_block_0.d2s_sp2k_f2_0.core 0.1618f
C243 d2s_block_0.d2s_casc_n_f2_0.x vinp 0.21699f
C244 iovdd a_812_18030# 0.16159f
C245 d2s_block_0.d2s_casc_n_f2_0.x d2s_block_0.d2s_casc_p_c2_0.pr 0.29544f
C246 d2s_block_0.d2s_casc_n_f2_0.y d2s_block_0.d2s_rhigh_f2_0.sb_C2 0.21505f
C247 d2s_block_0.d2s_casc_n_f2_0.x d2s_block_0.d2s_casc_n_f2_0.vbnc 3.02377f
C248 a_9374_29666# d2s_block_0.d2s_rhigh_f2_0.sa_C2 0.05012f
C249 a_9646_29666# a_9646_32196# 0.02519f
C250 d2s_block_0.bias_tree_n_f2_0.vabp d2s_cma_0.a 0.31599f
C251 a_10734_29666# d2s_block_0.d2s_ab_n_f2_0.vabn 0.01103f
C252 d2s_block_0.d2s_casc_n_f2_0.y d2s_block_0.d2s_rhigh_f2_0.sa_C2 1.84957f
C253 en_3v3 d2s_cma_0.a 0.05461f
C254 d2s_block_0.bias_tree_n_f2_0.vbpc d2s_block_0.d2s_ab_n_f2_0.l2 2.03019f
C255 a_10598_32196# d2s_block_0.d2s_ab_n_f2_0.vabn 0.14858f
C256 a_10190_29666# d2s_block_0.d2s_rhigh_f2_0.sb_B 0.04314f
C257 d2s_block_0.d2s_rhigh_f2_0.sb_C1 pad 2.68838f
C258 d2s_block_0.bias_tree_n_f2_0.vbpc d2s_block_0.d2s_rhigh_f2_0.sa_C1 0.04832f
C259 d2s_block_0.bias_tree_n_f2_0.vbpc iref 0.25785f
C260 a_11414_29666# d2s_block_0.d2s_rhigh_f2_0.sb_B 0.07713f
C261 d2s_block_0.bias_tree_n_f2_0.vbp d2s_block_0.d2s_rhigh_f2_0.sa_C1 0.27516f
C262 a_9510_29666# d2s_block_0.d2s_rhigh_f2_0.sb_B 0.02749f
C263 en_3v3_b Clamp_N_M1_wiring_0.b 0.44392f
C264 d2s_block_0.d2s_ab_n_f2_0.l1 d2s_cma_0.a 0.81303f
C265 d2s_block_0.bias_tree_n_f2_0.vbp iref 0.14242f
C266 d2s_block_0.d2s_rhigh_f2_0.sb_C1 d2s_block_0.d2s_rhigh_f2_0.sb_A 0.1631f
C267 a_11142_29666# d2s_block_0.d2s_rhigh_f2_0.sb_B 0.04459f
C268 a_11414_29666# a_11550_29666# 0.63642f
C269 d2s_block_0.d2s_rhigh_f2_0.sa_C1 vdd 1.01092f
C270 iovdd vinp 1.06556f
C271 d2s_block_0.bias_tree_n_f2_0.ni d2s_block_0.bias_tree_n_f2_0.vbpc 0.24074f
C272 iref vdd 0.97468f
C273 iovdd d2s_block_0.d2s_casc_n_f2_0.x 9.44335f
C274 iovdd d2s_block_0.d2s_casc_p_c2_0.pr 15.2407f
C275 iovdd d2s_block_0.d2s_casc_n_f2_0.vbnc 3.30292f
C276 d2s_block_0.d2s_rhigh_f2_0.sa_C1 a_9374_29666# 0.05763f
C277 d2s_block_0.bias_tree_n_f2_0.vbp d2s_block_0.bias_tree_n_f2_0.ni 0.74118f
C278 en_3v3_b d2s_block_0.d2s_rhigh_f2_0.sa_C2 0.0705f
C279 vref vinp 0.24444f
C280 d2s_block_0.d2s_casc_n_f2_0.x vref 0.70768f
C281 d2s_block_0.d2s_rhigh_f2_0.sa_A vinp 2.79506f
C282 a_9646_29666# vdd 0.01326f
C283 d2s_block_0.d2s_rhigh_f2_0.sa_A d2s_block_0.d2s_casc_n_f2_0.x 0.41947f
C284 d2s_block_0.d2s_casc_n_f2_0.y d2s_block_0.d2s_rhigh_f2_0.sa_C1 1.24175f
C285 d2s_block_0.d2s_casc_n_f2_0.x d2s_block_0.bias_tree_n_f2_0.vabp 0.16626f
C286 d2s_block_0.bias_tree_n_f2_0.vabp d2s_block_0.d2s_casc_p_c2_0.pr 0.01103f
C287 d2s_block_0.d2s_rhigh_f2_0.sa_A d2s_block_0.d2s_casc_n_f2_0.vbnc 0.46192f
C288 d2s_block_0.bias_tree_n_f2_0.ni vdd 5.18499f
C289 d2s_block_0.d2s_casc_p_c2_0.pl d2s_block_0.bias_tree_n_f2_0.vbpc 3.07095f
C290 d2s_block_0.d2s_ab_n_f2_0.vabn Clamp_N_M1_wiring_0.dabn 0.2642f
C291 d2s_block_0.d2s_sp2k_f2_1.core d2s_cma_0.a 33.6393f
C292 a_11278_29666# d2s_block_0.d2s_ab_n_f2_0.vabn 0.0373f
C293 d2s_block_0.d2s_casc_n_f2_0.x en_3v3 0.17638f
C294 en_3v3 d2s_block_0.d2s_casc_n_f2_0.vbnc 0.27478f
C295 d2s_block_0.d2s_rhigh_f2_0.sb_C2 a_9782_29666# 0.0209f
C296 a_812_18030# d2s_block_0.d2s_sp2k_f2_1.core 0.16662f
C297 d2s_block_0.d2s_ab_n_f2_0.vabn a_11006_29666# 0.01922f
C298 d2s_block_0.bias_tree_n_f2_0.vbpc d2s_block_0.sinks_6x6_f2_0.vbn 0.03128f
C299 a_10462_29666# d2s_block_0.d2s_rhigh_f2_0.sb_C2 0.02093f
C300 d2s_block_0.d2s_rhigh_f2_0.sb_C1 d2s_block_0.bias_tree_n_f2_0.vbpc 0.03244f
C301 d2s_block_0.bias_tree_n_f2_0.vbp d2s_block_0.sinks_6x6_f2_0.vbn 0.27681f
C302 vdd a_9918_32196# 0.12054f
C303 d2s_block_0.d2s_rhigh_f2_0.sa_C2 a_9782_29666# 0.06949f
C304 d2s_block_0.d2s_rhigh_f2_0.sb_C1 d2s_block_0.bias_tree_n_f2_0.vbp 0.23283f
C305 a_10462_29666# d2s_block_0.d2s_rhigh_f2_0.sa_C2 0.01669f
C306 a_10326_29666# d2s_block_0.d2s_rhigh_f2_0.sb_C2 0.02092f
C307 d2s_block_0.d2s_ab_n_f2_0.l1 d2s_block_0.d2s_casc_n_f2_0.x 0.35416f
C308 d2s_block_0.sinks_6x6_f2_0.vbn vdd 1.95274f
C309 d2s_block_0.d2s_ab_n_f2_0.l1 d2s_block_0.d2s_casc_n_f2_0.vbnc 6.86969f
C310 a_10598_29666# d2s_block_0.d2s_rhigh_f2_0.sb_C1 0.02576f
C311 d2s_block_0.d2s_rhigh_f2_0.sb_C1 vdd 0.08379f
C312 a_9510_29666# d2s_block_0.d2s_casc_n_f2_0.vbnc 0.05962f
C313 d2s_block_0.d2s_rhigh_f2_0.sb_B a_10870_29666# 0.04345f
C314 en_3v3_b iref 2.27275f
C315 a_10326_29666# d2s_block_0.d2s_rhigh_f2_0.sa_C2 0.02354f
C316 iovdd vref 5.59778f
C317 d2s_block_0.d2s_rhigh_f2_0.sb_C1 a_9374_29666# 0.02846f
C318 d2s_block_0.d2s_rhigh_f2_0.sa_A iovdd 0.7643f
C319 iovdd d2s_block_0.bias_tree_n_f2_0.vabp 4.69218f
C320 d2s_block_0.d2s_casc_n_f2_0.y d2s_block_0.sinks_6x6_f2_0.vbn 9.16822f
C321 d2s_block_0.d2s_casc_n_f2_0.y d2s_block_0.d2s_rhigh_f2_0.sb_C1 0.3288f
C322 d2s_block_0.d2s_rhigh_f2_0.sa_A vref 0.15231f
C323 iovdd en_3v3 2.0011f
C324 en_3v3_b d2s_block_0.bias_tree_n_f2_0.ni 0.15546f
C325 d2s_block_0.d2s_rhigh_f2_0.sb_B vinn 4.63917f
C326 d2s_block_0.bias_tree_n_f2_0.vabp en_3v3 0.25697f
C327 d2s_block_0.d2s_rhigh_f2_0.sa_C1 a_9782_29666# 0.12043f
C328 d2s_block_0.d2s_ab_n_f2_0.vabn d2s_block_0.d2s_rhigh_f2_0.sb_A 0.93711f
C329 d2s_block_0.d2s_ab_n_f2_0.l1 iovdd 2.75637f
C330 pad d2s_block_0.d2s_rhigh_f2_0.sa_B 0.03495f
C331 d2s_block_0.d2s_rhigh_f2_0.sb_B d2s_block_0.d2s_rhigh_f2_0.sb_C2 0.57959f
C332 a_9646_29666# a_9782_29666# 0.63642f
C333 en_3v3_b d2s_block_0.sinks_6x6_f2_0.vbn 0.15339f
C334 Clamp_N_M1_wiring_0.b d2s_cma_0.a 5.93786f
C335 d2s_block_0.d2s_ab_n_f2_0.l1 d2s_block_0.bias_tree_n_f2_0.vabp 0.69917f
C336 d2s_block_0.d2s_rhigh_f2_0.sb_A d2s_block_0.d2s_rhigh_f2_0.sa_B 2.00823f
C337 d2s_block_0.d2s_rhigh_f2_0.sb_B d2s_block_0.d2s_rhigh_f2_0.sa_C2 0.03789f
C338 d2s_block_0.d2s_rhigh_f2_0.sa_A a_9510_29666# 0.03839f
C339 d2s_block_0.d2s_ab_n_f2_0.l1 en_3v3 0.03629f
C340 iovdd d2s_block_0.d2s_sp2k_f2_1.core 4.49638f
C341 pad Clamp_N_M1_wiring_0.dabn 2.20295f
C342 d2s_block_0.bias_tree_n_f2_0.vbpc d2s_block_0.d2s_ab_n_f2_0.vabn 0.03067f
C343 a_10598_29666# a_10734_29666# 0.63642f
C344 d2s_block_0.bias_tree_n_f2_0.vbp d2s_block_0.d2s_ab_n_f2_0.vabn 0.29088f
C345 a_10734_29666# vdd 0.01326f
C346 vinp vinn 2.28356f
C347 d2s_block_0.d2s_rhigh_f2_0.sb_C1 a_9782_29666# 0.02558f
C348 d2s_block_0.d2s_casc_n_f2_0.x vinn 0.73094f
C349 a_10462_29580# d2s_block_0.d2s_rhigh_f2_0.sb_C2 0.12162f
C350 d2s_block_0.d2s_rhigh_f2_0.sb_C1 a_10462_29666# 0.02569f
C351 d2s_block_0.d2s_sp2k_f2_0.core d2s_cma_0.a 0.29723f
C352 d2s_block_0.d2s_ab_n_f2_0.vabn vdd 1.17406f
C353 a_10870_32196# a_10870_29666# 0.02728f
C354 a_10598_32196# a_10598_29666# 0.02713f
C355 d2s_block_0.bias_tree_n_f2_0.vbpc d2s_block_0.d2s_rhigh_f2_0.sa_B 0.05519f
C356 a_10598_32196# vdd 0.29675f
C357 d2s_block_0.d2s_rhigh_f2_0.sa_C1 d2s_block_0.d2s_rhigh_f2_0.sb_B 0.16445f
C358 d2s_block_0.d2s_casc_n_f2_0.x Clamp_N_M1_wiring_0.b 0.25852f
C359 a_10326_29666# d2s_block_0.d2s_rhigh_f2_0.sb_C1 0.02565f
C360 d2s_block_0.d2s_ab_n_f2_0.l2 d2s_cma_0.a 1.21313f
C361 d2s_block_0.bias_tree_n_f2_0.vbp d2s_block_0.d2s_rhigh_f2_0.sa_B 0.44672f
C362 Clamp_N_M1_wiring_0.b d2s_block_0.d2s_casc_n_f2_0.vbnc 6.87883f
C363 vinp d2s_block_0.d2s_rhigh_f2_0.sb_C2 0.11199f
C364 d2s_block_0.d2s_casc_n_f2_0.x d2s_block_0.d2s_rhigh_f2_0.sb_C2 1.16026f
C365 d2s_block_0.d2s_casc_n_f2_0.y d2s_block_0.d2s_ab_n_f2_0.vabn 1.2778f
C366 d2s_block_0.d2s_casc_n_f2_0.vbnc d2s_block_0.d2s_rhigh_f2_0.sb_C2 0.04184f
C367 a_9782_32196# a_9918_32196# 0.33426f
C368 d2s_block_0.d2s_rhigh_f2_0.sa_B vdd 0.09547f
C369 a_9646_29666# d2s_block_0.d2s_rhigh_f2_0.sb_B 0.03847f
C370 d2s_block_0.d2s_casc_n_f2_0.x d2s_block_0.d2s_rhigh_f2_0.sa_C2 0.28003f
C371 d2s_block_0.d2s_rhigh_f2_0.sa_C2 d2s_block_0.d2s_casc_p_c2_0.pr 0.03033f
C372 d2s_block_0.d2s_casc_n_f2_0.vbnc d2s_block_0.d2s_rhigh_f2_0.sa_C2 0.39817f
C373 a_9374_29666# d2s_block_0.d2s_rhigh_f2_0.sa_B 0.0463f
C374 a_10462_29580# a_10326_29580# 0.33426f
C375 d2s_block_0.d2s_casc_n_f2_0.y d2s_block_0.d2s_rhigh_f2_0.sa_B 1.99841f
C376 iovdd vinn 1.13707f
C377 a_9918_29666# d2s_block_0.d2s_rhigh_f2_0.sb_C2 0.0209f
C378 vref vinn 5.84531f
C379 en_3v3_b d2s_block_0.d2s_ab_n_f2_0.vabn 0.35174f
C380 a_11278_29666# vdd 0.01326f
C381 a_10734_32196# a_10870_32196# 0.55763f
C382 d2s_block_0.d2s_casc_p_c2_0.pl d2s_cma_0.a 0.88462f
C383 iovdd Clamp_N_M1_wiring_0.b 25.88f
C384 a_11006_29666# vdd 0.01326f
C385 a_10054_29666# vdd 0.01326f
C386 iovdd d2s_block_0.d2s_rhigh_f2_0.sb_C2 0.23279f
C387 a_9918_29666# d2s_block_0.d2s_rhigh_f2_0.sa_C2 0.11376f
C388 d2s_block_0.d2s_rhigh_f2_0.sb_C1 d2s_block_0.d2s_rhigh_f2_0.sb_B 1.47487f
C389 d2s_block_0.d2s_casc_n_f2_0.x d2s_block_0.d2s_ab_n_f2_0.l2 0.04055f
C390 d2s_block_0.d2s_ab_n_f2_0.l2 d2s_block_0.d2s_casc_p_c2_0.pr 5.91836f
C391 Clamp_N_M1_wiring_0.b d2s_block_0.bias_tree_n_f2_0.vabp 0.48786f
C392 d2s_block_0.d2s_casc_n_f2_0.x d2s_block_0.d2s_rhigh_f2_0.sa_C1 0.21017f
C393 iovdd d2s_block_0.d2s_rhigh_f2_0.sa_C2 0.81272f
C394 d2s_block_0.d2s_rhigh_f2_0.sa_C1 d2s_block_0.d2s_casc_p_c2_0.pr 0.02505f
C395 a_11006_29666# a_11006_32196# 0.02746f
C396 d2s_block_0.d2s_rhigh_f2_0.sa_A d2s_block_0.d2s_rhigh_f2_0.sb_C2 1.14606f
C397 d2s_block_0.d2s_rhigh_f2_0.sa_C1 d2s_block_0.d2s_casc_n_f2_0.vbnc 1.11584f
C398 iref d2s_block_0.d2s_casc_n_f2_0.vbnc 0.12819f
C399 a_15058_18030# pad 0.0581f
C400 Clamp_P_M1_wiring_0.dabp d2s_cma_0.a 0.77652f
C401 Clamp_N_M1_wiring_0.b en_3v3 0.04914f
C402 vref d2s_block_0.d2s_rhigh_f2_0.sa_C2 2.69046f
C403 pad d2s_block_0.bias_tree_n_f2_0.vbpc 0.0203f
C404 a_9646_29666# d2s_block_0.d2s_casc_n_f2_0.vbnc 0.04482f
C405 a_10598_32196# a_9510_32196# 0.21179f
C406 iovdd d2s_block_0.d2s_sp2k_f2_0.core 6.32776f
C407 d2s_block_0.d2s_ab_n_f2_0.l1 Clamp_N_M1_wiring_0.b 1.58264f
C408 d2s_block_0.bias_tree_n_f2_0.vbpc d2s_block_0.d2s_rhigh_f2_0.sb_A 2.21293f
C409 a_10190_29666# d2s_block_0.d2s_rhigh_f2_0.sb_C2 0.02091f
C410 pad vdd 0.0791f
C411 d2s_block_0.bias_tree_n_f2_0.vbp d2s_block_0.d2s_rhigh_f2_0.sb_A 0.3079f
C412 d2s_block_0.d2s_casc_p_c2_0.pl d2s_block_0.d2s_casc_p_c2_0.pr 10.0355f
C413 iovdd d2s_block_0.d2s_ab_n_f2_0.l2 47.2756f
C414 a_9510_29666# d2s_block_0.d2s_rhigh_f2_0.sb_C2 0.02089f
C415 a_10190_29666# d2s_block_0.d2s_rhigh_f2_0.sa_C2 0.03348f
C416 d2s_block_0.d2s_rhigh_f2_0.sb_A vdd 0.80516f
C417 a_11142_29666# d2s_block_0.d2s_rhigh_f2_0.sb_C2 0.02652f
C418 iovdd d2s_block_0.d2s_rhigh_f2_0.sa_C1 0.89579f
C419 a_10734_32196# a_11414_29666# 0.02719f
C420 d2s_block_0.d2s_casc_n_f2_0.y pad 0.08525f
C421 d2s_block_0.d2s_casc_n_f2_0.x d2s_block_0.sinks_6x6_f2_0.vbn 9.06373f
C422 iovdd iref 0.17627f
C423 a_9510_29666# d2s_block_0.d2s_rhigh_f2_0.sa_C2 0.04592f
C424 d2s_block_0.sinks_6x6_f2_0.vbn d2s_block_0.d2s_casc_n_f2_0.vbnc 0.20964f
C425 d2s_block_0.d2s_rhigh_f2_0.sb_A a_9374_29666# 0.0128f
C426 a_9646_32196# vdd 0.24583f
C427 d2s_block_0.d2s_rhigh_f2_0.sb_C1 vinp 0.10978f
C428 d2s_block_0.bias_tree_n_f2_0.vabp d2s_block_0.d2s_ab_n_f2_0.l2 0.60794f
C429 d2s_block_0.d2s_rhigh_f2_0.sb_C1 d2s_block_0.d2s_casc_n_f2_0.x 1.16358f
C430 vref d2s_block_0.d2s_rhigh_f2_0.sa_C1 2.69676f
C431 d2s_block_0.d2s_rhigh_f2_0.sb_C1 d2s_block_0.d2s_casc_n_f2_0.vbnc 0.05487f
C432 d2s_block_0.d2s_sp2k_f2_1.core Clamp_N_M1_wiring_0.b 0.11039f
C433 d2s_block_0.d2s_casc_n_f2_0.y d2s_block_0.d2s_rhigh_f2_0.sb_A 0.69671f
C434 en_3v3 d2s_block_0.d2s_ab_n_f2_0.l2 0.35277f
C435 iovdd d2s_block_0.bias_tree_n_f2_0.ni 0.16612f
C436 a_11550_29666# a_11686_29666# 0.63642f
C437 iref en_3v3 0.11463f
C438 a_10734_29666# d2s_block_0.d2s_rhigh_f2_0.sb_B 0.04331f
C439 a_9918_29666# a_9918_32196# 0.02634f
C440 d2s_block_0.bias_tree_n_f2_0.ni d2s_block_0.bias_tree_n_f2_0.vabp 0.55657f
C441 d2s_block_0.bias_tree_n_f2_0.vbp d2s_block_0.bias_tree_n_f2_0.vbpc 0.53763f
C442 d2s_block_0.d2s_ab_n_f2_0.l1 d2s_block_0.d2s_ab_n_f2_0.l2 0.56925f
C443 iovdd d2s_block_0.d2s_casc_p_c2_0.pl 18.3468f
C444 d2s_block_0.d2s_ab_n_f2_0.vabn d2s_block_0.d2s_rhigh_f2_0.sb_B 0.01173f
C445 d2s_block_0.bias_tree_n_f2_0.vbpc vdd 0.74307f
C446 d2s_block_0.bias_tree_n_f2_0.ni en_3v3 0.61404f
C447 d2s_block_0.d2s_rhigh_f2_0.sb_C1 a_9918_29666# 0.02559f
C448 d2s_block_0.d2s_ab_n_f2_0.vabn d2s_cma_0.a 0.21121f
C449 d2s_block_0.bias_tree_n_f2_0.vbp vdd 6.85536f
C450 iovdd d2s_block_0.sinks_6x6_f2_0.vbn 5.1611f
C451 a_11550_29666# d2s_block_0.d2s_ab_n_f2_0.vabn 0.07188f
C452 d2s_block_0.d2s_rhigh_f2_0.sa_C1 a_9510_29666# 0.07367f
C453 a_10598_29666# vdd 0.01326f
C454 iovdd d2s_block_0.d2s_rhigh_f2_0.sb_C1 0.31213f
C455 iref iovss 5.2928f
C456 vdd iovss 0.20725p
C457 d2s_block_0.d2s_casc_p_c2_0.pl iovss 1.52941f
C458 d2s_block_0.d2s_casc_p_c2_0.pr iovss 5.30357f
C459 d2s_block_0.d2s_ab_n_f2_0.l1 iovss 9.29697f
C460 d2s_block_0.d2s_casc_n_f2_0.x iovss 18.91412f
C461 d2s_block_0.d2s_casc_n_f2_0.y iovss 23.16874f
C462 a_11006_32196# iovss 1.05017f
C463 a_10870_32196# iovss 1.11157f
C464 a_10734_32196# iovss 1.1635f
C465 a_10598_32196# iovss 1.87881f
C466 a_10462_29580# iovss 1.15542f
C467 a_10326_29580# iovss 1.28099f
C468 a_10190_29580# iovss 1.38369f
C469 a_10054_29580# iovss 2.0911f
C470 a_9918_32196# iovss 1.04138f
C471 a_9782_32196# iovss 1.08734f
C472 a_9646_32196# iovss 1.15443f
C473 a_9510_32196# iovss 1.86057f
C474 d2s_block_0.d2s_rhigh_f2_0.sb_A iovss 11.3569f
C475 d2s_block_0.d2s_rhigh_f2_0.sa_C2 iovss 8.98262f
C476 d2s_block_0.d2s_rhigh_f2_0.sa_C1 iovss 5.45802f
C477 d2s_block_0.d2s_rhigh_f2_0.sb_B iovss 8.91756f
C478 d2s_block_0.d2s_rhigh_f2_0.sa_B iovss 7.41418f
C479 d2s_block_0.d2s_rhigh_f2_0.sb_C1 iovss 4.20856f
C480 d2s_block_0.d2s_rhigh_f2_0.sb_C2 iovss 4.87602f
C481 d2s_block_0.d2s_rhigh_f2_0.sa_A iovss 6.30954f
Rport_vss vss iovss 1
.ends
